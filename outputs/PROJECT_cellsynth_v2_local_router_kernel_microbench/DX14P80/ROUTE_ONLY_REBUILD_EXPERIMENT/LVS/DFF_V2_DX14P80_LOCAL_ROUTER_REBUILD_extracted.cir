* cell DFF_V2_DX14P80_LOCAL_ROUTER_REBUILD
* pin CLK,D
* pin Q
* pin VDD
* pin VSS
.SUBCKT DFF_V2_DX14P80_LOCAL_ROUTER_REBUILD 1 8 10 11
* net 1 CLK,D
* net 8 Q
* net 10 VDD
* net 11 VSS
* device instance $1 r0 *1 16.2,7 PMOS_VTG
M$1 9 1 9 10 PMOS_VTG L=0.05U W=0.5U AS=0.2875P AD=0.2875P PS=2.15U PD=2.15U
* device instance $2 r0 *1 14.7,7 PMOS_VTG
M$2 9 3 6 10 PMOS_VTG L=0.05U W=0.5U AS=0.2875P AD=0.2875P PS=2.15U PD=2.15U
* device instance $3 r0 *1 13.2,7 PMOS_VTG
M$3 2 3 5 10 PMOS_VTG L=0.05U W=0.5U AS=0.2875P AD=0.2875P PS=2.15U PD=2.15U
* device instance $4 r0 *1 11.7,7 PMOS_VTG
M$4 2 1 7 10 PMOS_VTG L=0.05U W=0.5U AS=0.2875P AD=0.2875P PS=2.15U PD=2.15U
* device instance $5 r0 *1 10.2,7 PMOS_VTG
M$5 9 8 10 10 PMOS_VTG L=0.05U W=0.5U AS=0.2875P AD=0.2875P PS=2.15U PD=2.15U
* device instance $6 r0 *1 2.7,7 PMOS_VTG
M$6 7 1 10 10 PMOS_VTG L=0.05U W=0.5U AS=0.2875P AD=0.2875P PS=2.15U PD=2.15U
* device instance $7 r0 *1 1.2,7 PMOS_VTG
M$7 3 1 10 10 PMOS_VTG L=0.05U W=0.5U AS=0.2875P AD=0.2875P PS=2.15U PD=2.15U
* device instance $8 r0 *1 8.7,7 PMOS_VTG
M$8 8 9 10 10 PMOS_VTG L=0.05U W=0.5U AS=0.2875P AD=0.2875P PS=2.15U PD=2.15U
* device instance $9 r0 *1 4.2,7 PMOS_VTG
M$9 4 2 10 10 PMOS_VTG L=0.05U W=0.5U AS=0.2875P AD=0.2875P PS=2.15U PD=2.15U
* device instance $10 r0 *1 7.2,7 PMOS_VTG
M$10 6 4 10 10 PMOS_VTG L=0.05U W=0.5U AS=0.2875P AD=0.2875P PS=2.15U PD=2.15U
* device instance $11 r0 *1 5.7,7 PMOS_VTG
M$11 5 4 10 10 PMOS_VTG L=0.05U W=0.5U AS=0.2875P AD=0.2875P PS=2.15U PD=2.15U
* device instance $12 r0 *1 29.5,2 NMOS_VTG
M$12 6 1 9 11 NMOS_VTG L=0.05U W=0.25U AS=0.14375P AD=0.14375P PS=1.65U PD=1.65U
* device instance $13 r0 *1 26.5,2 NMOS_VTG
M$13 7 3 2 11 NMOS_VTG L=0.05U W=0.25U AS=0.14375P AD=0.14375P PS=1.65U PD=1.65U
* device instance $14 r0 *1 25,2 NMOS_VTG
M$14 9 8 11 11 NMOS_VTG L=0.05U W=0.25U AS=0.14375P AD=0.14375P PS=1.65U
+ PD=1.65U
* device instance $15 r0 *1 19,2 NMOS_VTG
M$15 4 2 11 11 NMOS_VTG L=0.05U W=0.25U AS=0.14375P AD=0.14375P PS=1.65U
+ PD=1.65U
* device instance $16 r0 *1 16,2 NMOS_VTG
M$16 3 1 11 11 NMOS_VTG L=0.05U W=0.25U AS=0.14375P AD=0.14375P PS=1.65U
+ PD=1.65U
* device instance $17 r0 *1 28,2 NMOS_VTG
M$17 5 1 2 11 NMOS_VTG L=0.05U W=0.25U AS=0.14375P AD=0.14375P PS=1.65U PD=1.65U
* device instance $18 r0 *1 17.5,2 NMOS_VTG
M$18 7 1 11 11 NMOS_VTG L=0.05U W=0.25U AS=0.14375P AD=0.14375P PS=1.65U
+ PD=1.65U
* device instance $19 r0 *1 31,2 NMOS_VTG
M$19 9 3 9 11 NMOS_VTG L=0.05U W=0.25U AS=0.14375P AD=0.14375P PS=1.65U PD=1.65U
* device instance $20 r0 *1 20.5,2 NMOS_VTG
M$20 5 4 11 11 NMOS_VTG L=0.05U W=0.25U AS=0.14375P AD=0.14375P PS=1.65U
+ PD=1.65U
* device instance $21 r0 *1 22,2 NMOS_VTG
M$21 6 4 11 11 NMOS_VTG L=0.05U W=0.25U AS=0.14375P AD=0.14375P PS=1.65U
+ PD=1.65U
* device instance $22 r0 *1 23.5,2 NMOS_VTG
M$22 8 9 11 11 NMOS_VTG L=0.05U W=0.25U AS=0.14375P AD=0.14375P PS=1.65U
+ PD=1.65U
.ENDS DFF_V2_DX14P80_LOCAL_ROUTER_REBUILD
