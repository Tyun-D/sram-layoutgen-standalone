* cell CROSS_COUPLED_INV_LATCH
* pin Q
* pin QB
* pin VDD
* pin VSS
.SUBCKT CROSS_COUPLED_INV_LATCH 1 2 3 4
* net 1 Q
* net 2 QB
* net 3 VDD
* net 4 VSS
* device instance $1 r0 *1 2.7,7 PMOS_VTG
M$1 2 1 3 3 PMOS_VTG L=0.05U W=0.5U AS=0.2875P AD=0.2875P PS=2.15U PD=2.15U
* device instance $2 r0 *1 1.2,7 PMOS_VTG
M$2 1 2 3 3 PMOS_VTG L=0.05U W=0.5U AS=0.2875P AD=0.2875P PS=2.15U PD=2.15U
* device instance $3 r0 *1 2.7,2 NMOS_VTG
M$3 2 1 4 4 NMOS_VTG L=0.05U W=0.25U AS=0.14375P AD=0.14375P PS=1.65U PD=1.65U
* device instance $4 r0 *1 1.2,2 NMOS_VTG
M$4 1 2 4 4 NMOS_VTG L=0.05U W=0.25U AS=0.14375P AD=0.14375P PS=1.65U PD=1.65U
.ENDS CROSS_COUPLED_INV_LATCH
