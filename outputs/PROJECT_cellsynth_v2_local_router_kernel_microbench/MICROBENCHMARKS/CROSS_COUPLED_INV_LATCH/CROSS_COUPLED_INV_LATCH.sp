.subckt CROSS_COUPLED_INV_LATCH VDD VSS Q QB
M0 Q QB VDD VDD PMOS_VTG W=0.5U L=0.05U
M1 Q QB VSS VSS NMOS_VTG W=0.25U L=0.05U
M2 QB Q VDD VDD PMOS_VTG W=0.5U L=0.05U
M3 QB Q VSS VSS NMOS_VTG W=0.25U L=0.05U
.ends CROSS_COUPLED_INV_LATCH
.end
