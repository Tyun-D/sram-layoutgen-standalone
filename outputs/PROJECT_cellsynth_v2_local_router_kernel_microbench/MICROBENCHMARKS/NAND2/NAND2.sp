.subckt NAND2 VDD VSS A B Y
M0 Y A VDD VDD PMOS_VTG W=0.5U L=0.05U
M1 Y B VDD VDD PMOS_VTG W=0.5U L=0.05U
M2 Y A n1 VSS NMOS_VTG W=0.25U L=0.05U
M3 n1 B VSS VSS NMOS_VTG W=0.25U L=0.05U
.ends NAND2
.end
