* cell DFF_TG4_INV7_FPDK45_e6da842830d7
* pin CLK
* pin D
* pin Q
* pin VDD
* pin VSS
.SUBCKT DFF_TG4_INV7_FPDK45_e6da842830d7 1 3 10 12 13
* net 1 CLK
* net 3 D
* net 10 Q
* net 12 VDD
* net 13 VSS
* device instance $1 r0 *1 6.525,0.3275 NMOS_VTG
M$1 5 1 7 13 NMOS_VTG L=0.05U W=0.25U AS=0.031875P AD=0.031875P PS=0.755U
+ PD=0.755U
* device instance $2 r0 *1 12.7625,0.3275 NMOS_VTG
M$2 9 2 11 13 NMOS_VTG L=0.05U W=0.25U AS=0.031875P AD=0.031875P PS=0.755U
+ PD=0.755U
* device instance $3 r0 *1 2.7825,0.3275 NMOS_VTG
M$3 5 2 4 13 NMOS_VTG L=0.05U W=0.25U AS=0.031875P AD=0.031875P PS=0.755U
+ PD=0.755U
* device instance $4 r0 *1 9.02,0.3275 NMOS_VTG
M$4 9 1 8 13 NMOS_VTG L=0.05U W=0.25U AS=0.031875P AD=0.031875P PS=0.755U
+ PD=0.755U
* device instance $5 r0 *1 6.525,1.4325 PMOS_VTG
M$5 5 2 7 12 PMOS_VTG L=0.05U W=0.5U AS=0.06375P AD=0.06375P PS=1.255U PD=1.255U
* device instance $6 r0 *1 12.7625,1.4325 PMOS_VTG
M$6 9 1 11 12 PMOS_VTG L=0.05U W=0.5U AS=0.06375P AD=0.06375P PS=1.255U
+ PD=1.255U
* device instance $7 r0 *1 2.7825,1.4325 PMOS_VTG
M$7 5 1 4 12 PMOS_VTG L=0.05U W=0.5U AS=0.06375P AD=0.06375P PS=1.255U PD=1.255U
* device instance $8 r0 *1 9.02,1.4325 PMOS_VTG
M$8 9 2 8 12 PMOS_VTG L=0.05U W=0.5U AS=0.06375P AD=0.06375P PS=1.255U PD=1.255U
* device instance $9 r0 *1 0.2875,0.2825 NMOS_VTG
M$9 2 1 13 13 NMOS_VTG L=0.05U W=0.25U AS=0.031875P AD=0.031875P PS=0.755U
+ PD=0.755U
* device instance $10 r0 *1 1.535,0.2825 NMOS_VTG
M$10 4 3 13 13 NMOS_VTG L=0.05U W=0.25U AS=0.031875P AD=0.031875P PS=0.755U
+ PD=0.755U
* device instance $11 r0 *1 4.03,0.2825 NMOS_VTG
M$11 6 5 13 13 NMOS_VTG L=0.05U W=0.25U AS=0.031875P AD=0.031875P PS=0.755U
+ PD=0.755U
* device instance $12 r0 *1 7.7725,0.2825 NMOS_VTG
M$12 8 6 13 13 NMOS_VTG L=0.05U W=0.25U AS=0.031875P AD=0.031875P PS=0.755U
+ PD=0.755U
* device instance $13 r0 *1 5.2775,0.2825 NMOS_VTG
M$13 7 6 13 13 NMOS_VTG L=0.05U W=0.25U AS=0.031875P AD=0.031875P PS=0.755U
+ PD=0.755U
* device instance $14 r0 *1 10.2675,0.2825 NMOS_VTG
M$14 10 9 13 13 NMOS_VTG L=0.05U W=0.25U AS=0.031875P AD=0.031875P PS=0.755U
+ PD=0.755U
* device instance $15 r0 *1 11.515,0.2825 NMOS_VTG
M$15 11 10 13 13 NMOS_VTG L=0.05U W=0.25U AS=0.031875P AD=0.031875P PS=0.755U
+ PD=0.755U
* device instance $16 r0 *1 0.2875,1.4775 PMOS_VTG
M$16 2 1 12 12 PMOS_VTG L=0.05U W=0.5U AS=0.06375P AD=0.06375P PS=1.255U
+ PD=1.255U
* device instance $17 r0 *1 1.535,1.4775 PMOS_VTG
M$17 4 3 12 12 PMOS_VTG L=0.05U W=0.5U AS=0.06375P AD=0.06375P PS=1.255U
+ PD=1.255U
* device instance $18 r0 *1 4.03,1.4775 PMOS_VTG
M$18 6 5 12 12 PMOS_VTG L=0.05U W=0.5U AS=0.06375P AD=0.06375P PS=1.255U
+ PD=1.255U
* device instance $19 r0 *1 7.7725,1.4775 PMOS_VTG
M$19 8 6 12 12 PMOS_VTG L=0.05U W=0.5U AS=0.06375P AD=0.06375P PS=1.255U
+ PD=1.255U
* device instance $20 r0 *1 5.2775,1.4775 PMOS_VTG
M$20 7 6 12 12 PMOS_VTG L=0.05U W=0.5U AS=0.06375P AD=0.06375P PS=1.255U
+ PD=1.255U
* device instance $21 r0 *1 10.2675,1.4775 PMOS_VTG
M$21 10 9 12 12 PMOS_VTG L=0.05U W=0.5U AS=0.06375P AD=0.06375P PS=1.255U
+ PD=1.255U
* device instance $22 r0 *1 11.515,1.4775 PMOS_VTG
M$22 11 10 12 12 PMOS_VTG L=0.05U W=0.5U AS=0.06375P AD=0.06375P PS=1.255U
+ PD=1.255U
.ENDS DFF_TG4_INV7_FPDK45_e6da842830d7
