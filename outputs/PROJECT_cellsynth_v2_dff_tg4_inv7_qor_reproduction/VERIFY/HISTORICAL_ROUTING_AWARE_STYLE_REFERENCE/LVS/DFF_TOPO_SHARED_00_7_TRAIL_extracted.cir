* cell DFF_TOPO_SHARED_00_7_TRAIL
* pin NWELL
* pin PWELL
.SUBCKT DFF_TOPO_SHARED_00_7_TRAIL 49 50
* net 49 NWELL
* net 50 PWELL
* device instance $1 r0 *1 0.4375,1.73 PMOS_VTG
M$1 26 38 25 49 PMOS_VTG L=0.05U W=0.5U AS=0.12625P AD=0.038125P PS=1.505U
+ PD=0.6525U
* device instance $2 r0 *1 0.64,1.73 PMOS_VTG
M$2 27 39 26 49 PMOS_VTG L=0.05U W=0.5U AS=0.038125P AD=0.0375P PS=0.6525U
+ PD=0.65U
* device instance $3 r0 *1 0.84,1.73 PMOS_VTG
M$3 28 40 27 49 PMOS_VTG L=0.05U W=0.5U AS=0.0375P AD=0.038125P PS=0.65U
+ PD=0.6525U
* device instance $4 r0 *1 1.0425,1.73 PMOS_VTG
M$4 29 41 28 49 PMOS_VTG L=0.05U W=0.5U AS=0.038125P AD=0.038125P PS=0.6525U
+ PD=0.6525U
* device instance $5 r0 *1 1.245,1.73 PMOS_VTG
M$5 30 42 29 49 PMOS_VTG L=0.05U W=0.5U AS=0.038125P AD=0.038125P PS=0.6525U
+ PD=0.6525U
* device instance $6 r0 *1 1.4475,1.73 PMOS_VTG
M$6 31 43 30 49 PMOS_VTG L=0.05U W=0.5U AS=0.038125P AD=0.038125P PS=0.6525U
+ PD=0.6525U
* device instance $7 r0 *1 1.65,1.73 PMOS_VTG
M$7 32 44 31 49 PMOS_VTG L=0.05U W=0.5U AS=0.038125P AD=0.0375P PS=0.6525U
+ PD=0.65U
* device instance $8 r0 *1 1.85,1.73 PMOS_VTG
M$8 33 45 32 49 PMOS_VTG L=0.05U W=0.5U AS=0.0375P AD=0.038125P PS=0.65U
+ PD=0.6525U
* device instance $9 r0 *1 2.0525,1.73 PMOS_VTG
M$9 34 46 33 49 PMOS_VTG L=0.05U W=0.5U AS=0.038125P AD=0.038125P PS=0.6525U
+ PD=0.6525U
* device instance $10 r0 *1 2.255,1.73 PMOS_VTG
M$10 35 47 34 49 PMOS_VTG L=0.05U W=0.5U AS=0.038125P AD=0.12625P PS=0.6525U
+ PD=1.505U
* device instance $11 r0 *1 2.935,1.73 PMOS_VTG
M$11 37 48 36 49 PMOS_VTG L=0.05U W=0.5U AS=0.12625P AD=0.125P PS=1.505U PD=1.5U
* device instance $12 r0 *1 2.935,0.605 NMOS_VTG
M$12 13 15 12 50 NMOS_VTG L=0.05U W=0.25U AS=0.063125P AD=0.0625P PS=1.005U
+ PD=1U
* device instance $13 r0 *1 0.4375,0.605 NMOS_VTG
M$13 2 14 1 50 NMOS_VTG L=0.05U W=0.25U AS=0.063125P AD=0.0190625P PS=1.005U
+ PD=0.4025U
* device instance $14 r0 *1 0.64,0.605 NMOS_VTG
M$14 3 16 2 50 NMOS_VTG L=0.05U W=0.25U AS=0.0190625P AD=0.01875P PS=0.4025U
+ PD=0.4U
* device instance $15 r0 *1 0.84,0.605 NMOS_VTG
M$15 4 17 3 50 NMOS_VTG L=0.05U W=0.25U AS=0.01875P AD=0.0190625P PS=0.4U
+ PD=0.4025U
* device instance $16 r0 *1 1.0425,0.605 NMOS_VTG
M$16 5 18 4 50 NMOS_VTG L=0.05U W=0.25U AS=0.0190625P AD=0.0190625P PS=0.4025U
+ PD=0.4025U
* device instance $17 r0 *1 1.245,0.605 NMOS_VTG
M$17 6 19 5 50 NMOS_VTG L=0.05U W=0.25U AS=0.0190625P AD=0.0190625P PS=0.4025U
+ PD=0.4025U
* device instance $18 r0 *1 1.4475,0.605 NMOS_VTG
M$18 7 21 6 50 NMOS_VTG L=0.05U W=0.25U AS=0.0190625P AD=0.0190625P PS=0.4025U
+ PD=0.4025U
* device instance $19 r0 *1 1.65,0.605 NMOS_VTG
M$19 8 23 7 50 NMOS_VTG L=0.05U W=0.25U AS=0.0190625P AD=0.01875P PS=0.4025U
+ PD=0.4U
* device instance $20 r0 *1 1.85,0.605 NMOS_VTG
M$20 9 24 8 50 NMOS_VTG L=0.05U W=0.25U AS=0.01875P AD=0.0190625P PS=0.4U
+ PD=0.4025U
* device instance $21 r0 *1 2.0525,0.605 NMOS_VTG
M$21 10 22 9 50 NMOS_VTG L=0.05U W=0.25U AS=0.0190625P AD=0.0190625P PS=0.4025U
+ PD=0.4025U
* device instance $22 r0 *1 2.255,0.605 NMOS_VTG
M$22 11 20 10 50 NMOS_VTG L=0.05U W=0.25U AS=0.0190625P AD=0.063125P PS=0.4025U
+ PD=1.005U
.ENDS DFF_TOPO_SHARED_00_7_TRAIL
