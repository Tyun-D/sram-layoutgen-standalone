* cell DFF_V2_SHARED_DIFF_P1p45_NEG_OPEN_Q
* pin CLK
* pin D
* pin Q
* pin VDD
* pin VSS
.SUBCKT DFF_V2_SHARED_DIFF_P1p45_NEG_OPEN_Q 4 5 12 13 14
* net 4 CLK
* net 5 D
* net 12 Q
* net 13 VDD
* net 14 VSS
* device instance $1 r0 *1 1.925,7 PMOS_VTG
M$1 13 4 3 13 PMOS_VTG L=0.05U W=0.5U AS=0.4P AD=0.35P PS=2.6U PD=1.9U
* device instance $2 r0 *1 3.375,7 PMOS_VTG
M$2 1 5 13 13 PMOS_VTG L=0.05U W=0.5U AS=0.35P AD=0.35P PS=1.9U PD=1.9U
* device instance $3 r0 *1 4.825,7 PMOS_VTG
M$3 6 4 1 13 PMOS_VTG L=0.05U W=0.5U AS=0.35P AD=0.35P PS=1.9U PD=1.9U
* device instance $4 r0 *1 6.275,7 PMOS_VTG
M$4 2 3 6 13 PMOS_VTG L=0.05U W=0.5U AS=0.35P AD=0.35P PS=1.9U PD=1.9U
* device instance $5 r0 *1 7.725,7 PMOS_VTG
M$5 13 11 2 13 PMOS_VTG L=0.05U W=0.5U AS=0.35P AD=0.35P PS=1.9U PD=1.9U
* device instance $6 r0 *1 9.175,7 PMOS_VTG
M$6 11 6 13 13 PMOS_VTG L=0.05U W=0.5U AS=0.35P AD=0.4P PS=1.9U PD=2.6U
* device instance $7 r0 *1 1.925,5.75 PMOS_VTG
M$7 7 11 13 13 PMOS_VTG L=0.05U W=0.5U AS=0.4P AD=0.35P PS=2.6U PD=1.9U
* device instance $8 r0 *1 3.375,5.75 PMOS_VTG
M$8 8 3 7 13 PMOS_VTG L=0.05U W=0.5U AS=0.35P AD=0.35P PS=1.9U PD=1.9U
* device instance $9 r0 *1 4.825,5.75 PMOS_VTG
M$9 9 4 8 13 PMOS_VTG L=0.05U W=0.5U AS=0.35P AD=0.35P PS=1.9U PD=1.9U
* device instance $10 r0 *1 6.275,5.75 PMOS_VTG
M$10 13 12 9 13 PMOS_VTG L=0.05U W=0.5U AS=0.35P AD=0.35P PS=1.9U PD=1.9U
* device instance $11 r0 *1 7.725,5.75 PMOS_VTG
M$11 10 8 13 13 PMOS_VTG L=0.05U W=0.5U AS=0.35P AD=0.4P PS=1.9U PD=2.6U
* device instance $12 r0 *1 1.925,2 NMOS_VTG
M$12 14 4 3 14 NMOS_VTG L=0.05U W=0.25U AS=0.2P AD=0.175P PS=2.1U PD=1.65U
* device instance $13 r0 *1 3.375,2 NMOS_VTG
M$13 1 5 14 14 NMOS_VTG L=0.05U W=0.25U AS=0.175P AD=0.175P PS=1.65U PD=1.65U
* device instance $14 r0 *1 4.825,2 NMOS_VTG
M$14 6 3 1 14 NMOS_VTG L=0.05U W=0.25U AS=0.175P AD=0.175P PS=1.65U PD=1.65U
* device instance $15 r0 *1 6.275,2 NMOS_VTG
M$15 2 4 6 14 NMOS_VTG L=0.05U W=0.25U AS=0.175P AD=0.175P PS=1.65U PD=1.65U
* device instance $16 r0 *1 7.725,2 NMOS_VTG
M$16 14 11 2 14 NMOS_VTG L=0.05U W=0.25U AS=0.175P AD=0.175P PS=1.65U PD=1.65U
* device instance $17 r0 *1 9.175,2 NMOS_VTG
M$17 11 6 14 14 NMOS_VTG L=0.05U W=0.25U AS=0.175P AD=0.2P PS=1.65U PD=2.1U
* device instance $18 r0 *1 1.925,3.05 NMOS_VTG
M$18 7 11 14 14 NMOS_VTG L=0.05U W=0.25U AS=0.2P AD=0.175P PS=2.1U PD=1.65U
* device instance $19 r0 *1 3.375,3.05 NMOS_VTG
M$19 8 4 7 14 NMOS_VTG L=0.05U W=0.25U AS=0.175P AD=0.175P PS=1.65U PD=1.65U
* device instance $20 r0 *1 4.825,3.05 NMOS_VTG
M$20 9 3 8 14 NMOS_VTG L=0.05U W=0.25U AS=0.175P AD=0.175P PS=1.65U PD=1.65U
* device instance $21 r0 *1 6.275,3.05 NMOS_VTG
M$21 14 12 9 14 NMOS_VTG L=0.05U W=0.25U AS=0.175P AD=0.175P PS=1.65U PD=1.65U
* device instance $22 r0 *1 7.725,3.05 NMOS_VTG
M$22 10 8 14 14 NMOS_VTG L=0.05U W=0.25U AS=0.175P AD=0.2P PS=1.65U PD=2.1U
.ENDS DFF_V2_SHARED_DIFF_P1p45_NEG_OPEN_Q
