* cell DFF_V2_SHARED_DIFF_P1p1
* pin D
* pin CLK,Q
* pin VDD
* pin VSS
.SUBCKT DFF_V2_SHARED_DIFF_P1p1 3 6 7 8
* net 3 D
* net 6 CLK,Q
* net 7 VDD
* net 8 VSS
* device instance $1 r0 *1 1.75,7 PMOS_VTG
M$1 7 6 6 7 PMOS_VTG L=0.05U W=1.5U AS=0.8375P AD=0.8875P PS=5.35U PD=6.05U
* device instance $2 r0 *1 2.85,7 PMOS_VTG
M$2 1 3 7 7 PMOS_VTG L=0.05U W=0.5U AS=0.2625P AD=0.2625P PS=1.55U PD=1.55U
* device instance $3 r0 *1 3.95,7 PMOS_VTG
M$3 6 6 1 7 PMOS_VTG L=0.05U W=0.5U AS=0.2625P AD=0.2625P PS=1.55U PD=1.55U
* device instance $4 r0 *1 5.05,7 PMOS_VTG
M$4 2 6 6 7 PMOS_VTG L=0.05U W=0.5U AS=0.2625P AD=0.2625P PS=1.55U PD=1.55U
* device instance $5 r0 *1 6.15,7 PMOS_VTG
M$5 7 6 2 7 PMOS_VTG L=0.05U W=0.5U AS=0.2625P AD=0.2625P PS=1.55U PD=1.55U
* device instance $7 r0 *1 1.75,5.75 PMOS_VTG
M$7 4 6 7 7 PMOS_VTG L=0.05U W=0.5U AS=0.3125P AD=0.2625P PS=2.25U PD=1.55U
* device instance $8 r0 *1 2.85,5.75 PMOS_VTG
M$8 6 6 4 7 PMOS_VTG L=0.05U W=0.5U AS=0.2625P AD=0.2625P PS=1.55U PD=1.55U
* device instance $9 r0 *1 3.95,5.75 PMOS_VTG
M$9 5 6 6 7 PMOS_VTG L=0.05U W=0.5U AS=0.2625P AD=0.2625P PS=1.55U PD=1.55U
* device instance $10 r0 *1 5.05,5.75 PMOS_VTG
M$10 7 6 5 7 PMOS_VTG L=0.05U W=0.5U AS=0.2625P AD=0.2625P PS=1.55U PD=1.55U
* device instance $12 r0 *1 1.75,3.05 NMOS_VTG
M$12 4 6 8 8 NMOS_VTG L=0.05U W=0.25U AS=0.15625P AD=0.13125P PS=1.75U PD=1.3U
* device instance $13 r0 *1 2.85,3.05 NMOS_VTG
M$13 6 6 4 8 NMOS_VTG L=0.05U W=0.25U AS=0.13125P AD=0.13125P PS=1.3U PD=1.3U
* device instance $14 r0 *1 3.95,3.05 NMOS_VTG
M$14 5 6 6 8 NMOS_VTG L=0.05U W=0.25U AS=0.13125P AD=0.13125P PS=1.3U PD=1.3U
* device instance $15 r0 *1 5.05,3.05 NMOS_VTG
M$15 8 6 5 8 NMOS_VTG L=0.05U W=0.25U AS=0.13125P AD=0.13125P PS=1.3U PD=1.3U
* device instance $16 r0 *1 6.15,3.05 NMOS_VTG
M$16 6 6 8 8 NMOS_VTG L=0.05U W=0.75U AS=0.41875P AD=0.44375P PS=4.35U PD=4.8U
* device instance $18 r0 *1 2.85,2 NMOS_VTG
M$18 1 3 8 8 NMOS_VTG L=0.05U W=0.25U AS=0.13125P AD=0.13125P PS=1.3U PD=1.3U
* device instance $19 r0 *1 3.95,2 NMOS_VTG
M$19 6 6 1 8 NMOS_VTG L=0.05U W=0.25U AS=0.13125P AD=0.13125P PS=1.3U PD=1.3U
* device instance $20 r0 *1 5.05,2 NMOS_VTG
M$20 2 6 6 8 NMOS_VTG L=0.05U W=0.25U AS=0.13125P AD=0.13125P PS=1.3U PD=1.3U
* device instance $21 r0 *1 6.15,2 NMOS_VTG
M$21 8 6 2 8 NMOS_VTG L=0.05U W=0.25U AS=0.13125P AD=0.13125P PS=1.3U PD=1.3U
.ENDS DFF_V2_SHARED_DIFF_P1p1
