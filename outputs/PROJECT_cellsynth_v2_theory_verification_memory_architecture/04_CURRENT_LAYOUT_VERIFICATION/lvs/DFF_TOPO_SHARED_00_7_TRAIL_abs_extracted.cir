* cell DFF_TOPO_SHARED_00_7_TRAIL
.SUBCKT DFF_TOPO_SHARED_00_7_TRAIL
* net 61 NWELL
* net 62 PWELL
* device instance $1 r0 *1 0.4375,1.73 PMOS_VTG
M$1 36 48 35 61 PMOS_VTG L=0.05U W=0.5U AS=0.12625P AD=0.038125P PS=1.505U
+ PD=0.6525U
* device instance $2 r0 *1 0.64,1.73 PMOS_VTG
M$2 37 49 36 61 PMOS_VTG L=0.05U W=0.5U AS=0.038125P AD=0.0375P PS=0.6525U
+ PD=0.65U
* device instance $3 r0 *1 0.84,1.73 PMOS_VTG
M$3 38 50 37 61 PMOS_VTG L=0.05U W=0.5U AS=0.0375P AD=0.038125P PS=0.65U
+ PD=0.6525U
* device instance $4 r0 *1 1.0425,1.73 PMOS_VTG
M$4 39 51 38 61 PMOS_VTG L=0.05U W=0.5U AS=0.038125P AD=0.038125P PS=0.6525U
+ PD=0.6525U
* device instance $5 r0 *1 1.245,1.73 PMOS_VTG
M$5 40 52 39 61 PMOS_VTG L=0.05U W=0.5U AS=0.038125P AD=0.038125P PS=0.6525U
+ PD=0.6525U
* device instance $6 r0 *1 1.4475,1.73 PMOS_VTG
M$6 41 53 40 61 PMOS_VTG L=0.05U W=0.5U AS=0.038125P AD=0.038125P PS=0.6525U
+ PD=0.6525U
* device instance $7 r0 *1 1.65,1.73 PMOS_VTG
M$7 42 54 41 61 PMOS_VTG L=0.05U W=0.5U AS=0.038125P AD=0.0375P PS=0.6525U
+ PD=0.65U
* device instance $8 r0 *1 1.85,1.73 PMOS_VTG
M$8 43 55 42 61 PMOS_VTG L=0.05U W=0.5U AS=0.0375P AD=0.038125P PS=0.65U
+ PD=0.6525U
* device instance $9 r0 *1 2.0525,1.73 PMOS_VTG
M$9 44 56 43 61 PMOS_VTG L=0.05U W=0.5U AS=0.038125P AD=0.038125P PS=0.6525U
+ PD=0.6525U
* device instance $10 r0 *1 2.255,1.73 PMOS_VTG
M$10 45 57 44 61 PMOS_VTG L=0.05U W=0.5U AS=0.038125P AD=0.12625P PS=0.6525U
+ PD=1.505U
* device instance $11 r0 *1 2.935,1.73 PMOS_VTG
M$11 47 59 46 61 PMOS_VTG L=0.05U W=0.5U AS=0.12625P AD=0.125P PS=1.505U PD=1.5U
* device instance $12 r0 *1 2.935,0.605 NMOS_VTG
M$12 14 25 13 62 NMOS_VTG L=0.05U W=0.25U AS=0.063125P AD=0.0625P PS=1.005U
+ PD=1U
* device instance $13 r0 *1 0.4375,0.605 NMOS_VTG
M$13 3 24 2 62 NMOS_VTG L=0.05U W=0.25U AS=0.063125P AD=0.0190625P PS=1.005U
+ PD=0.4025U
* device instance $14 r0 *1 0.64,0.605 NMOS_VTG
M$14 4 26 3 62 NMOS_VTG L=0.05U W=0.25U AS=0.0190625P AD=0.01875P PS=0.4025U
+ PD=0.4U
* device instance $15 r0 *1 0.84,0.605 NMOS_VTG
M$15 5 27 4 62 NMOS_VTG L=0.05U W=0.25U AS=0.01875P AD=0.0190625P PS=0.4U
+ PD=0.4025U
* device instance $16 r0 *1 1.0425,0.605 NMOS_VTG
M$16 6 28 5 62 NMOS_VTG L=0.05U W=0.25U AS=0.0190625P AD=0.0190625P PS=0.4025U
+ PD=0.4025U
* device instance $17 r0 *1 1.245,0.605 NMOS_VTG
M$17 7 29 6 62 NMOS_VTG L=0.05U W=0.25U AS=0.0190625P AD=0.0190625P PS=0.4025U
+ PD=0.4025U
* device instance $18 r0 *1 1.4475,0.605 NMOS_VTG
M$18 8 31 7 62 NMOS_VTG L=0.05U W=0.25U AS=0.0190625P AD=0.0190625P PS=0.4025U
+ PD=0.4025U
* device instance $19 r0 *1 1.65,0.605 NMOS_VTG
M$19 9 33 8 62 NMOS_VTG L=0.05U W=0.25U AS=0.0190625P AD=0.01875P PS=0.4025U
+ PD=0.4U
* device instance $20 r0 *1 1.85,0.605 NMOS_VTG
M$20 10 34 9 62 NMOS_VTG L=0.05U W=0.25U AS=0.01875P AD=0.0190625P PS=0.4U
+ PD=0.4025U
* device instance $21 r0 *1 2.0525,0.605 NMOS_VTG
M$21 11 32 10 62 NMOS_VTG L=0.05U W=0.25U AS=0.0190625P AD=0.0190625P
+ PS=0.4025U PD=0.4025U
* device instance $22 r0 *1 2.255,0.605 NMOS_VTG
M$22 12 30 11 62 NMOS_VTG L=0.05U W=0.25U AS=0.0190625P AD=0.063125P PS=0.4025U
+ PD=1.005U
.ENDS DFF_TOPO_SHARED_00_7_TRAIL
