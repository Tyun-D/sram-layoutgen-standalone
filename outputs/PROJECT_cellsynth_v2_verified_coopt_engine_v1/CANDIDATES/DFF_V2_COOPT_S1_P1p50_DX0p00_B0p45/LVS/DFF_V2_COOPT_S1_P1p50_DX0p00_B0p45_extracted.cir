* cell DFF_V2_COOPT_S1_P1p50_DX0p00_B0p45
* pin CLK
* pin D
* pin Q
* pin VDD,VSS
.SUBCKT DFF_V2_COOPT_S1_P1p50_DX0p00_B0p45 3 4 6 7
* net 3 CLK
* net 4 D
* net 6 Q
* net 7 VDD,VSS
* device instance $1 r0 *1 16.2,7 PMOS_VTG
M$1 2 3 2 7 PMOS_VTG L=0.05U W=1U AS=0.575P AD=0.575P PS=4.3U PD=4.3U
* device instance $3 r0 *1 13.2,7 PMOS_VTG
M$3 1 3 1 7 PMOS_VTG L=0.05U W=1U AS=0.575P AD=0.575P PS=4.3U PD=4.3U
* device instance $5 r0 *1 10.2,7 PMOS_VTG
M$5 2 6 7 7 PMOS_VTG L=0.05U W=0.5U AS=0.2875P AD=0.2875P PS=2.15U PD=2.15U
* device instance $6 r0 *1 2.7,7 PMOS_VTG
M$6 1 4 7 7 PMOS_VTG L=0.05U W=0.5U AS=0.2875P AD=0.2875P PS=2.15U PD=2.15U
* device instance $7 r0 *1 1.2,7 PMOS_VTG
M$7 3 3 7 7 PMOS_VTG L=0.05U W=0.5U AS=0.2875P AD=0.2875P PS=2.15U PD=2.15U
* device instance $8 r0 *1 8.7,7 PMOS_VTG
M$8 6 2 7 7 PMOS_VTG L=0.05U W=0.5U AS=0.2875P AD=0.2875P PS=2.15U PD=2.15U
* device instance $9 r0 *1 4.2,7 PMOS_VTG
M$9 5 1 7 7 PMOS_VTG L=0.05U W=0.5U AS=0.2875P AD=0.2875P PS=2.15U PD=2.15U
* device instance $10 r0 *1 7.2,7 PMOS_VTG
M$10 2 5 7 7 PMOS_VTG L=0.05U W=0.5U AS=0.2875P AD=0.2875P PS=2.15U PD=2.15U
* device instance $11 r0 *1 5.7,7 PMOS_VTG
M$11 1 5 7 7 PMOS_VTG L=0.05U W=0.5U AS=0.2875P AD=0.2875P PS=2.15U PD=2.15U
* device instance $12 r0 *1 16.2,2 NMOS_VTG
M$12 2 3 2 7 NMOS_VTG L=0.05U W=0.5U AS=0.2875P AD=0.2875P PS=3.3U PD=3.3U
* device instance $14 r0 *1 13.2,2 NMOS_VTG
M$14 1 3 1 7 NMOS_VTG L=0.05U W=0.5U AS=0.2875P AD=0.2875P PS=3.3U PD=3.3U
* device instance $16 r0 *1 10.2,2 NMOS_VTG
M$16 2 6 7 7 NMOS_VTG L=0.05U W=0.25U AS=0.14375P AD=0.14375P PS=1.65U PD=1.65U
* device instance $17 r0 *1 1.2,2 NMOS_VTG
M$17 3 3 7 7 NMOS_VTG L=0.05U W=0.25U AS=0.14375P AD=0.14375P PS=1.65U PD=1.65U
* device instance $18 r0 *1 2.7,2 NMOS_VTG
M$18 1 4 7 7 NMOS_VTG L=0.05U W=0.25U AS=0.14375P AD=0.14375P PS=1.65U PD=1.65U
* device instance $19 r0 *1 4.2,2 NMOS_VTG
M$19 5 1 7 7 NMOS_VTG L=0.05U W=0.25U AS=0.14375P AD=0.14375P PS=1.65U PD=1.65U
* device instance $20 r0 *1 8.7,2 NMOS_VTG
M$20 6 2 7 7 NMOS_VTG L=0.05U W=0.25U AS=0.14375P AD=0.14375P PS=1.65U PD=1.65U
* device instance $21 r0 *1 5.7,2 NMOS_VTG
M$21 1 5 7 7 NMOS_VTG L=0.05U W=0.25U AS=0.14375P AD=0.14375P PS=1.65U PD=1.65U
* device instance $22 r0 *1 7.2,2 NMOS_VTG
M$22 2 5 7 7 NMOS_VTG L=0.05U W=0.25U AS=0.14375P AD=0.14375P PS=1.65U PD=1.65U
.ENDS DFF_V2_COOPT_S1_P1p50_DX0p00_B0p45
