* cell DFF_V2_COOPT_S1_P1p50_DX0p35_B0p42
* pin VDD
* pin CLK,D,Q,VSS
.SUBCKT DFF_V2_COOPT_S1_P1p50_DX0p35_B0p42 1 2
* net 1 VDD
* net 2 CLK,D,Q,VSS
* device instance $1 r0 *1 16.2,7 PMOS_VTG
M$1 2 2 2 1 PMOS_VTG L=0.05U W=2U AS=1.15P AD=1.15P PS=8.6U PD=8.6U
* device instance $5 r0 *1 10.2,7 PMOS_VTG
M$5 2 2 1 1 PMOS_VTG L=0.05U W=3.5U AS=2.0125P AD=2.0125P PS=15.05U PD=15.05U
* device instance $12 r0 *1 16.55,2 NMOS_VTG
M$12 2 2 2 2 NMOS_VTG L=0.05U W=2.75U AS=1.58125P AD=1.58125P PS=18.15U
+ PD=18.15U
.ENDS DFF_V2_COOPT_S1_P1p50_DX0p35_B0p42
