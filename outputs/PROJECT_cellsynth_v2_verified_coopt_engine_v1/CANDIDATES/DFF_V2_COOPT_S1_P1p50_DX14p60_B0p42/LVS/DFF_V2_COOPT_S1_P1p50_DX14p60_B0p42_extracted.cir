* cell DFF_V2_COOPT_S1_P1p50_DX14p60_B0p42
* pin D
* pin Q
* pin VDD
* pin CLK,VSS
.SUBCKT DFF_V2_COOPT_S1_P1p50_DX14p60_B0p42 1 7 9 10
* net 1 D
* net 7 Q
* net 9 VDD
* net 10 CLK,VSS
* device instance $1 r0 *1 16.2,7 PMOS_VTG
M$1 8 10 10 9 PMOS_VTG L=0.05U W=0.5U AS=0.2875P AD=0.2875P PS=2.15U PD=2.15U
* device instance $2 r0 *1 14.7,7 PMOS_VTG
M$2 8 10 5 9 PMOS_VTG L=0.05U W=0.5U AS=0.2875P AD=0.2875P PS=2.15U PD=2.15U
* device instance $3 r0 *1 13.2,7 PMOS_VTG
M$3 2 10 4 9 PMOS_VTG L=0.05U W=0.5U AS=0.2875P AD=0.2875P PS=2.15U PD=2.15U
* device instance $4 r0 *1 11.7,7 PMOS_VTG
M$4 2 10 6 9 PMOS_VTG L=0.05U W=0.5U AS=0.2875P AD=0.2875P PS=2.15U PD=2.15U
* device instance $5 r0 *1 10.2,7 PMOS_VTG
M$5 10 7 9 9 PMOS_VTG L=0.05U W=0.5U AS=0.2875P AD=0.2875P PS=2.15U PD=2.15U
* device instance $6 r0 *1 2.7,7 PMOS_VTG
M$6 6 1 9 9 PMOS_VTG L=0.05U W=0.5U AS=0.2875P AD=0.2875P PS=2.15U PD=2.15U
* device instance $7 r0 *1 1.2,7 PMOS_VTG
M$7 10 10 9 9 PMOS_VTG L=0.05U W=0.5U AS=0.2875P AD=0.2875P PS=2.15U PD=2.15U
* device instance $8 r0 *1 8.7,7 PMOS_VTG
M$8 7 8 9 9 PMOS_VTG L=0.05U W=0.5U AS=0.2875P AD=0.2875P PS=2.15U PD=2.15U
* device instance $9 r0 *1 4.2,7 PMOS_VTG
M$9 3 2 9 9 PMOS_VTG L=0.05U W=0.5U AS=0.2875P AD=0.2875P PS=2.15U PD=2.15U
* device instance $10 r0 *1 7.2,7 PMOS_VTG
M$10 5 3 9 9 PMOS_VTG L=0.05U W=0.5U AS=0.2875P AD=0.2875P PS=2.15U PD=2.15U
* device instance $11 r0 *1 5.7,7 PMOS_VTG
M$11 4 3 9 9 PMOS_VTG L=0.05U W=0.5U AS=0.2875P AD=0.2875P PS=2.15U PD=2.15U
* device instance $12 r0 *1 30.8,2 NMOS_VTG
M$12 10 10 8 10 NMOS_VTG L=0.05U W=0.25U AS=0.14375P AD=0.14375P PS=1.65U
+ PD=1.65U
* device instance $13 r0 *1 29.3,2 NMOS_VTG
M$13 5 10 8 10 NMOS_VTG L=0.05U W=0.25U AS=0.14375P AD=0.14375P PS=1.65U
+ PD=1.65U
* device instance $14 r0 *1 27.8,2 NMOS_VTG
M$14 4 10 2 10 NMOS_VTG L=0.05U W=0.25U AS=0.14375P AD=0.14375P PS=1.65U
+ PD=1.65U
* device instance $15 r0 *1 24.8,2 NMOS_VTG
M$15 10 7 10 10 NMOS_VTG L=0.05U W=0.25U AS=0.14375P AD=0.14375P PS=1.65U
+ PD=1.65U
* device instance $16 r0 *1 15.8,2 NMOS_VTG
M$16 10 10 10 10 NMOS_VTG L=0.05U W=0.25U AS=0.14375P AD=0.14375P PS=1.65U
+ PD=1.65U
* device instance $17 r0 *1 21.8,2 NMOS_VTG
M$17 5 3 10 10 NMOS_VTG L=0.05U W=0.25U AS=0.14375P AD=0.14375P PS=1.65U
+ PD=1.65U
* device instance $18 r0 *1 17.3,2 NMOS_VTG
M$18 6 1 10 10 NMOS_VTG L=0.05U W=0.25U AS=0.14375P AD=0.14375P PS=1.65U
+ PD=1.65U
* device instance $19 r0 *1 18.8,2 NMOS_VTG
M$19 3 2 10 10 NMOS_VTG L=0.05U W=0.25U AS=0.14375P AD=0.14375P PS=1.65U
+ PD=1.65U
* device instance $20 r0 *1 20.3,2 NMOS_VTG
M$20 4 3 10 10 NMOS_VTG L=0.05U W=0.25U AS=0.14375P AD=0.14375P PS=1.65U
+ PD=1.65U
* device instance $21 r0 *1 23.3,2 NMOS_VTG
M$21 7 8 10 10 NMOS_VTG L=0.05U W=0.25U AS=0.14375P AD=0.14375P PS=1.65U
+ PD=1.65U
* device instance $22 r0 *1 26.3,2 NMOS_VTG
M$22 6 10 2 10 NMOS_VTG L=0.05U W=0.25U AS=0.14375P AD=0.14375P PS=1.65U
+ PD=1.65U
.ENDS DFF_V2_COOPT_S1_P1p50_DX14p60_B0p42
