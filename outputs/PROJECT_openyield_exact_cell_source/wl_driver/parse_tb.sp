* OpenYield/current-source exact canonical SPICE for WL_DRIVER_OPENYIELD_EXACT
* authority_level=CURRENT_SOURCE_BOUND_PARENT_EXACT
.model NMOS_VTG NMOS level=1 VTO=0.45 KP=120e-6
.model PMOS_VTG PMOS level=1 VTO=-0.45 KP=40e-6
.subckt wl_driver_openyield_exact VDD VSS A B WL
MNAND_MP_A NAND_Z A VDD VDD PMOS_VTG W=270n L=50n
MNAND_MP_B NAND_Z B VDD VDD PMOS_VTG W=270n L=50n
MNAND_MN_A NINT A Z VSS NMOS_VTG W=180n L=50n
MNAND_MN_B VSS B NINT VSS NMOS_VTG W=180n L=50n
MINV_MP0 WL NAND_Z VDD VDD PMOS_VTG W=270n L=50n
MINV_MN0 WL NAND_Z VSS VSS NMOS_VTG W=90n L=50n
.ends wl_driver_openyield_exact

.end
