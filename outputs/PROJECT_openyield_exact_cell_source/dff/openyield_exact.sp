* OpenYield/current-source exact canonical SPICE for DFF_OPENYIELD_EXACT
* authority_level=CURRENT_SOURCE_BOUND_COMPOSITE_EXACT
.model NMOS_VTG NMOS level=1 VTO=0.45 KP=120e-6
.model PMOS_VTG PMOS level=1 VTO=-0.45 KP=40e-6
.subckt dff_openyield_exact VDD VSS D Q CLK
Minv1_clk_MP CLKB CLK VDD VDD PMOS_VTG W=500n L=50n
Minv1_clk_MN CLKB CLK VSS VSS NMOS_VTG W=250n L=50n
Minv2_D_MP D_b D VDD VDD PMOS_VTG W=500n L=50n
Minv2_D_MN D_b D VSS VSS NMOS_VTG W=250n L=50n
Mtg1_MP z1 CLK D_b VDD PMOS_VTG W=500n L=50n
Mtg1_MN z1 CLKB D_b VSS NMOS_VTG W=250n L=50n
Minv3_MP z2 z1 VDD VDD PMOS_VTG W=500n L=50n
Minv3_MN z2 z1 VSS VSS NMOS_VTG W=250n L=50n
Minv4_MP z3 z2 VDD VDD PMOS_VTG W=500n L=50n
Minv4_MN z3 z2 VSS VSS NMOS_VTG W=250n L=50n
Mtg2_MP z1 CLKB z3 VDD PMOS_VTG W=500n L=50n
Mtg2_MN z1 CLK z3 VSS NMOS_VTG W=250n L=50n
Minv5_MP z4 z2 VDD VDD PMOS_VTG W=500n L=50n
Minv5_MN z4 z2 VSS VSS NMOS_VTG W=250n L=50n
Mtg3_MP z5 CLKB z4 VDD PMOS_VTG W=500n L=50n
Mtg3_MN z5 CLK z4 VSS NMOS_VTG W=250n L=50n
Minv6_MP Q z5 VDD VDD PMOS_VTG W=500n L=50n
Minv6_MN Q z5 VSS VSS NMOS_VTG W=250n L=50n
Minv7_MP QB Q VDD VDD PMOS_VTG W=500n L=50n
Minv7_MN QB Q VSS VSS NMOS_VTG W=250n L=50n
Mtg4_MP z5 CLK QB VDD PMOS_VTG W=500n L=50n
Mtg4_MN z5 CLKB QB VSS NMOS_VTG W=250n L=50n
.ends dff_openyield_exact
.end
