* LCLayout exploratory attempt for gen_inv
.subckt gen_inv A Z VDD VSS
* placeholder source-exact netlist extraction pending
.ends gen_inv
