* LCLayout exploratory attempt for gen_nand2
.subckt gen_nand2 A Z VDD VSS
* placeholder source-exact netlist extraction pending
.ends gen_nand2
