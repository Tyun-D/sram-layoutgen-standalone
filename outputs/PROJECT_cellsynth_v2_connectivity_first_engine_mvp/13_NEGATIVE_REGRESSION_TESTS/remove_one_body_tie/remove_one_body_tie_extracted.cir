* cell DFF_V2_CONNECTIVITY_BASELINE
* pin CLK
* pin D
* pin VDD
* pin Q
* pin NWELL
* pin VSS
.SUBCKT DFF_V2_CONNECTIVITY_BASELINE 1 2 6 10 13 14
* net 1 CLK
* net 2 D
* net 6 VDD
* net 10 Q
* net 13 NWELL
* net 14 VSS
* device instance $1 r0 *1 16.2,7 PMOS_VTG
M$1 12 1 11 13 PMOS_VTG L=0.05U W=0.5U AS=0.2875P AD=0.2875P PS=2.15U PD=2.15U
* device instance $2 r0 *1 14.7,7 PMOS_VTG
M$2 12 7 5 13 PMOS_VTG L=0.05U W=0.5U AS=0.2875P AD=0.2875P PS=2.15U PD=2.15U
* device instance $3 r0 *1 13.2,7 PMOS_VTG
M$3 3 7 4 13 PMOS_VTG L=0.05U W=0.5U AS=0.2875P AD=0.2875P PS=2.15U PD=2.15U
* device instance $4 r0 *1 11.7,7 PMOS_VTG
M$4 3 1 8 13 PMOS_VTG L=0.05U W=0.5U AS=0.2875P AD=0.2875P PS=2.15U PD=2.15U
* device instance $5 r0 *1 10.2,7 PMOS_VTG
M$5 11 10 6 13 PMOS_VTG L=0.05U W=0.5U AS=0.2875P AD=0.2875P PS=2.15U PD=2.15U
* device instance $6 r0 *1 2.7,7 PMOS_VTG
M$6 8 2 6 13 PMOS_VTG L=0.05U W=0.5U AS=0.2875P AD=0.2875P PS=2.15U PD=2.15U
* device instance $7 r0 *1 1.2,7 PMOS_VTG
M$7 7 1 6 13 PMOS_VTG L=0.05U W=0.5U AS=0.2875P AD=0.2875P PS=2.15U PD=2.15U
* device instance $8 r0 *1 8.7,7 PMOS_VTG
M$8 10 12 6 13 PMOS_VTG L=0.05U W=0.5U AS=0.2875P AD=0.2875P PS=2.15U PD=2.15U
* device instance $9 r0 *1 4.2,7 PMOS_VTG
M$9 9 3 6 13 PMOS_VTG L=0.05U W=0.5U AS=0.2875P AD=0.2875P PS=2.15U PD=2.15U
* device instance $10 r0 *1 7.2,7 PMOS_VTG
M$10 5 9 6 13 PMOS_VTG L=0.05U W=0.5U AS=0.2875P AD=0.2875P PS=2.15U PD=2.15U
* device instance $11 r0 *1 5.7,7 PMOS_VTG
M$11 4 9 6 13 PMOS_VTG L=0.05U W=0.5U AS=0.2875P AD=0.2875P PS=2.15U PD=2.15U
* device instance $12 r0 *1 34.2,2 NMOS_VTG
M$12 11 7 12 14 NMOS_VTG L=0.05U W=0.25U AS=0.14375P AD=0.14375P PS=1.65U
+ PD=1.65U
* device instance $13 r0 *1 29.7,2 NMOS_VTG
M$13 8 7 3 14 NMOS_VTG L=0.05U W=0.25U AS=0.14375P AD=0.14375P PS=1.65U PD=1.65U
* device instance $14 r0 *1 32.7,2 NMOS_VTG
M$14 5 1 12 14 NMOS_VTG L=0.05U W=0.25U AS=0.14375P AD=0.14375P PS=1.65U
+ PD=1.65U
* device instance $15 r0 *1 28.2,2 NMOS_VTG
M$15 11 10 14 14 NMOS_VTG L=0.05U W=0.25U AS=0.14375P AD=0.14375P PS=1.65U
+ PD=1.65U
* device instance $16 r0 *1 19.2,2 NMOS_VTG
M$16 7 1 14 14 NMOS_VTG L=0.05U W=0.25U AS=0.14375P AD=0.14375P PS=1.65U
+ PD=1.65U
* device instance $17 r0 *1 31.2,2 NMOS_VTG
M$17 4 1 3 14 NMOS_VTG L=0.05U W=0.25U AS=0.14375P AD=0.14375P PS=1.65U PD=1.65U
* device instance $18 r0 *1 26.7,2 NMOS_VTG
M$18 10 12 14 14 NMOS_VTG L=0.05U W=0.25U AS=0.14375P AD=0.14375P PS=1.65U
+ PD=1.65U
* device instance $19 r0 *1 20.7,2 NMOS_VTG
M$19 8 2 14 14 NMOS_VTG L=0.05U W=0.25U AS=0.14375P AD=0.14375P PS=1.65U
+ PD=1.65U
* device instance $20 r0 *1 23.7,2 NMOS_VTG
M$20 4 9 14 14 NMOS_VTG L=0.05U W=0.25U AS=0.14375P AD=0.14375P PS=1.65U
+ PD=1.65U
* device instance $21 r0 *1 25.2,2 NMOS_VTG
M$21 5 9 14 14 NMOS_VTG L=0.05U W=0.25U AS=0.14375P AD=0.14375P PS=1.65U
+ PD=1.65U
* device instance $22 r0 *1 22.2,2 NMOS_VTG
M$22 9 3 14 14 NMOS_VTG L=0.05U W=0.25U AS=0.14375P AD=0.14375P PS=1.65U
+ PD=1.65U
.ENDS DFF_V2_CONNECTIVITY_BASELINE
