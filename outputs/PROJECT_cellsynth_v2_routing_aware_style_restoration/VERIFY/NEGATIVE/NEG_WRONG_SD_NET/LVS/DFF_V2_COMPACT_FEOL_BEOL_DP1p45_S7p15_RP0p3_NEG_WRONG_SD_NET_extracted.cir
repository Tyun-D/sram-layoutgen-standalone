* cell DFF_V2_COMPACT_FEOL_BEOL_DP1p45_S7p15_RP0p3_NEG_WRONG_SD_NET
* pin CLK
* pin D
* pin Q
* pin VDD
* pin VSS
.SUBCKT DFF_V2_COMPACT_FEOL_BEOL_DP1p45_S7p15_RP0p3_NEG_WRONG_SD_NET 4 5 12 15
+ 16
* net 4 CLK
* net 5 D
* net 12 Q
* net 15 VDD
* net 16 VSS
* device instance $1 r0 *1 1.925,7 PMOS_VTG
M$1 15 4 1 15 PMOS_VTG L=0.05U W=0.5U AS=0.4P AD=0.35P PS=2.6U PD=1.9U
* device instance $2 r0 *1 3.375,7 PMOS_VTG
M$2 2 5 15 15 PMOS_VTG L=0.05U W=0.5U AS=0.35P AD=0.35P PS=1.9U PD=1.9U
* device instance $3 r0 *1 4.825,7 PMOS_VTG
M$3 14 4 2 15 PMOS_VTG L=0.05U W=0.5U AS=0.35P AD=0.35P PS=1.9U PD=1.9U
* device instance $4 r0 *1 6.275,7 PMOS_VTG
M$4 3 1 14 15 PMOS_VTG L=0.05U W=0.5U AS=0.35P AD=0.35P PS=1.9U PD=1.9U
* device instance $5 r0 *1 7.725,7 PMOS_VTG
M$5 15 11 3 15 PMOS_VTG L=0.05U W=0.5U AS=0.35P AD=0.35P PS=1.9U PD=1.9U
* device instance $6 r0 *1 9.175,7 PMOS_VTG
M$6 11 13 15 15 PMOS_VTG L=0.05U W=0.5U AS=0.35P AD=0.4P PS=1.9U PD=2.6U
* device instance $7 r0 *1 1.925,5.75 PMOS_VTG
M$7 8 11 15 15 PMOS_VTG L=0.05U W=0.5U AS=0.4P AD=0.35P PS=2.6U PD=1.9U
* device instance $8 r0 *1 3.375,5.75 PMOS_VTG
M$8 9 1 8 15 PMOS_VTG L=0.05U W=0.5U AS=0.35P AD=0.35P PS=1.9U PD=1.9U
* device instance $9 r0 *1 4.825,5.75 PMOS_VTG
M$9 10 4 9 15 PMOS_VTG L=0.05U W=0.5U AS=0.35P AD=0.35P PS=1.9U PD=1.9U
* device instance $10 r0 *1 6.275,5.75 PMOS_VTG
M$10 15 12 10 15 PMOS_VTG L=0.05U W=0.5U AS=0.35P AD=0.35P PS=1.9U PD=1.9U
* device instance $11 r0 *1 7.725,5.75 PMOS_VTG
M$11 12 9 15 15 PMOS_VTG L=0.05U W=0.5U AS=0.35P AD=0.4P PS=1.9U PD=2.6U
* device instance $12 r0 *1 1.925,2 NMOS_VTG
M$12 16 4 1 16 NMOS_VTG L=0.05U W=0.25U AS=0.2P AD=0.175P PS=2.1U PD=1.65U
* device instance $13 r0 *1 3.375,2 NMOS_VTG
M$13 2 5 16 16 NMOS_VTG L=0.05U W=0.25U AS=0.175P AD=0.175P PS=1.65U PD=1.65U
* device instance $14 r0 *1 4.825,2 NMOS_VTG
M$14 6 1 2 16 NMOS_VTG L=0.05U W=0.25U AS=0.175P AD=0.175P PS=1.65U PD=1.65U
* device instance $15 r0 *1 6.275,2 NMOS_VTG
M$15 3 4 6 16 NMOS_VTG L=0.05U W=0.25U AS=0.175P AD=0.175P PS=1.65U PD=1.65U
* device instance $16 r0 *1 7.725,2 NMOS_VTG
M$16 16 11 3 16 NMOS_VTG L=0.05U W=0.25U AS=0.175P AD=0.175P PS=1.65U PD=1.65U
* device instance $17 r0 *1 9.175,2 NMOS_VTG
M$17 11 7 16 16 NMOS_VTG L=0.05U W=0.25U AS=0.175P AD=0.2P PS=1.65U PD=2.1U
* device instance $18 r0 *1 1.925,3.05 NMOS_VTG
M$18 8 11 16 16 NMOS_VTG L=0.05U W=0.25U AS=0.2P AD=0.175P PS=2.1U PD=1.65U
* device instance $19 r0 *1 3.375,3.05 NMOS_VTG
M$19 9 4 8 16 NMOS_VTG L=0.05U W=0.25U AS=0.175P AD=0.175P PS=1.65U PD=1.65U
* device instance $20 r0 *1 4.825,3.05 NMOS_VTG
M$20 10 1 9 16 NMOS_VTG L=0.05U W=0.25U AS=0.175P AD=0.175P PS=1.65U PD=1.65U
* device instance $21 r0 *1 6.275,3.05 NMOS_VTG
M$21 16 12 10 16 NMOS_VTG L=0.05U W=0.25U AS=0.175P AD=0.175P PS=1.65U PD=1.65U
* device instance $22 r0 *1 7.725,3.05 NMOS_VTG
M$22 12 9 16 16 NMOS_VTG L=0.05U W=0.25U AS=0.175P AD=0.2P PS=1.65U PD=2.1U
.ENDS DFF_V2_COMPACT_FEOL_BEOL_DP1p45_S7p15_RP0p3_NEG_WRONG_SD_NET
