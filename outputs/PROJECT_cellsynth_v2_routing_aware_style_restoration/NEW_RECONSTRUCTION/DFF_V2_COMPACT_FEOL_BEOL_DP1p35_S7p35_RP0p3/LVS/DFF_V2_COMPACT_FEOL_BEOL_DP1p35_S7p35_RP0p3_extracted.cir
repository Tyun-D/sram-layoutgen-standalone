* cell DFF_V2_COMPACT_FEOL_BEOL_DP1p35_S7p35_RP0p3
* pin D
* pin CLK,Q
* pin VDD
* pin VSS
.SUBCKT DFF_V2_COMPACT_FEOL_BEOL_DP1p35_S7p35_RP0p3 2 4 8 9
* net 2 D
* net 4 CLK,Q
* net 8 VDD
* net 9 VSS
* device instance $1 r0 *1 1.875,7 PMOS_VTG
M$1 8 4 4 8 PMOS_VTG L=0.05U W=1U AS=0.7P AD=0.7P PS=4.3U PD=4.3U
* device instance $2 r0 *1 3.225,7 PMOS_VTG
M$2 3 2 8 8 PMOS_VTG L=0.05U W=0.5U AS=0.325P AD=0.325P PS=1.8U PD=1.8U
* device instance $3 r0 *1 4.575,7 PMOS_VTG
M$3 4 4 3 8 PMOS_VTG L=0.05U W=0.5U AS=0.325P AD=0.325P PS=1.8U PD=1.8U
* device instance $4 r0 *1 5.925,7 PMOS_VTG
M$4 1 4 4 8 PMOS_VTG L=0.05U W=0.5U AS=0.325P AD=0.325P PS=1.8U PD=1.8U
* device instance $5 r0 *1 7.275,7 PMOS_VTG
M$5 8 4 1 8 PMOS_VTG L=0.05U W=0.5U AS=0.325P AD=0.325P PS=1.8U PD=1.8U
* device instance $7 r0 *1 1.875,5.75 PMOS_VTG
M$7 5 4 8 8 PMOS_VTG L=0.05U W=0.5U AS=0.375P AD=0.325P PS=2.5U PD=1.8U
* device instance $8 r0 *1 3.225,5.75 PMOS_VTG
M$8 6 4 5 8 PMOS_VTG L=0.05U W=0.5U AS=0.325P AD=0.325P PS=1.8U PD=1.8U
* device instance $9 r0 *1 4.575,5.75 PMOS_VTG
M$9 7 4 6 8 PMOS_VTG L=0.05U W=0.5U AS=0.325P AD=0.325P PS=1.8U PD=1.8U
* device instance $10 r0 *1 5.925,5.75 PMOS_VTG
M$10 8 4 7 8 PMOS_VTG L=0.05U W=0.5U AS=0.325P AD=0.325P PS=1.8U PD=1.8U
* device instance $11 r0 *1 7.275,5.75 PMOS_VTG
M$11 4 6 8 8 PMOS_VTG L=0.05U W=0.5U AS=0.325P AD=0.375P PS=1.8U PD=2.5U
* device instance $12 r0 *1 1.875,3.05 NMOS_VTG
M$12 5 4 9 9 NMOS_VTG L=0.05U W=0.25U AS=0.1875P AD=0.1625P PS=2U PD=1.55U
* device instance $13 r0 *1 3.225,3.05 NMOS_VTG
M$13 6 4 5 9 NMOS_VTG L=0.05U W=0.25U AS=0.1625P AD=0.1625P PS=1.55U PD=1.55U
* device instance $14 r0 *1 4.575,3.05 NMOS_VTG
M$14 7 4 6 9 NMOS_VTG L=0.05U W=0.25U AS=0.1625P AD=0.1625P PS=1.55U PD=1.55U
* device instance $15 r0 *1 5.925,3.05 NMOS_VTG
M$15 9 4 7 9 NMOS_VTG L=0.05U W=0.25U AS=0.1625P AD=0.1625P PS=1.55U PD=1.55U
* device instance $16 r0 *1 7.275,3.05 NMOS_VTG
M$16 4 6 9 9 NMOS_VTG L=0.05U W=0.25U AS=0.1625P AD=0.1875P PS=1.55U PD=2U
* device instance $17 r0 *1 1.875,2 NMOS_VTG
M$17 9 4 4 9 NMOS_VTG L=0.05U W=0.5U AS=0.35P AD=0.35P PS=3.55U PD=3.55U
* device instance $18 r0 *1 3.225,2 NMOS_VTG
M$18 3 2 9 9 NMOS_VTG L=0.05U W=0.25U AS=0.1625P AD=0.1625P PS=1.55U PD=1.55U
* device instance $19 r0 *1 4.575,2 NMOS_VTG
M$19 4 4 3 9 NMOS_VTG L=0.05U W=0.25U AS=0.1625P AD=0.1625P PS=1.55U PD=1.55U
* device instance $20 r0 *1 5.925,2 NMOS_VTG
M$20 1 4 4 9 NMOS_VTG L=0.05U W=0.25U AS=0.1625P AD=0.1625P PS=1.55U PD=1.55U
* device instance $21 r0 *1 7.275,2 NMOS_VTG
M$21 9 4 1 9 NMOS_VTG L=0.05U W=0.25U AS=0.1625P AD=0.1625P PS=1.55U PD=1.55U
.ENDS DFF_V2_COMPACT_FEOL_BEOL_DP1p35_S7p35_RP0p3
