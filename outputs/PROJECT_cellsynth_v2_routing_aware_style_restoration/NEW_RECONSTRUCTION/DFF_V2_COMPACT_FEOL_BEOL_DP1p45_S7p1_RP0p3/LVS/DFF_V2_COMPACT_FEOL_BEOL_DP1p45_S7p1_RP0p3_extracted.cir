* cell DFF_V2_COMPACT_FEOL_BEOL_DP1p45_S7p1_RP0p3
* pin CLK
* pin D
* pin Q,VDD,VSS
.SUBCKT DFF_V2_COMPACT_FEOL_BEOL_DP1p45_S7p1_RP0p3 2 3 8
* net 2 CLK
* net 3 D
* net 8 Q,VDD,VSS
* device instance $1 r0 *1 1.925,7 PMOS_VTG
M$1 8 2 8 8 PMOS_VTG L=0.05U W=0.5U AS=0.4P AD=0.35P PS=2.6U PD=1.9U
* device instance $2 r0 *1 3.375,7 PMOS_VTG
M$2 1 3 8 8 PMOS_VTG L=0.05U W=0.5U AS=0.35P AD=0.35P PS=1.9U PD=1.9U
* device instance $3 r0 *1 4.825,7 PMOS_VTG
M$3 4 2 1 8 PMOS_VTG L=0.05U W=0.5U AS=0.35P AD=0.35P PS=1.9U PD=1.9U
* device instance $4 r0 *1 6.275,7 PMOS_VTG
M$4 8 8 4 8 PMOS_VTG L=0.05U W=0.5U AS=0.35P AD=0.35P PS=1.9U PD=1.9U
* device instance $5 r0 *1 7.725,7 PMOS_VTG
M$5 8 7 8 8 PMOS_VTG L=0.05U W=1U AS=0.75P AD=0.7P PS=4.5U PD=3.8U
* device instance $6 r0 *1 9.175,7 PMOS_VTG
M$6 7 4 8 8 PMOS_VTG L=0.05U W=0.5U AS=0.35P AD=0.4P PS=1.9U PD=2.6U
* device instance $8 r0 *1 3.375,5.75 PMOS_VTG
M$8 5 8 8 8 PMOS_VTG L=0.05U W=0.5U AS=0.35P AD=0.35P PS=1.9U PD=1.9U
* device instance $9 r0 *1 4.825,5.75 PMOS_VTG
M$9 6 2 5 8 PMOS_VTG L=0.05U W=0.5U AS=0.35P AD=0.35P PS=1.9U PD=1.9U
* device instance $10 r0 *1 6.275,5.75 PMOS_VTG
M$10 8 8 6 8 PMOS_VTG L=0.05U W=0.5U AS=0.35P AD=0.35P PS=1.9U PD=1.9U
* device instance $11 r0 *1 7.725,5.75 PMOS_VTG
M$11 8 5 8 8 PMOS_VTG L=0.05U W=0.5U AS=0.35P AD=0.4P PS=1.9U PD=2.6U
* device instance $12 r0 *1 1.925,2 NMOS_VTG
M$12 8 2 8 8 NMOS_VTG L=0.05U W=0.25U AS=0.2P AD=0.175P PS=2.1U PD=1.65U
* device instance $13 r0 *1 3.375,2 NMOS_VTG
M$13 1 3 8 8 NMOS_VTG L=0.05U W=0.25U AS=0.175P AD=0.175P PS=1.65U PD=1.65U
* device instance $14 r0 *1 4.825,2 NMOS_VTG
M$14 4 8 1 8 NMOS_VTG L=0.05U W=0.25U AS=0.175P AD=0.175P PS=1.65U PD=1.65U
* device instance $15 r0 *1 6.275,2 NMOS_VTG
M$15 8 2 4 8 NMOS_VTG L=0.05U W=0.25U AS=0.175P AD=0.175P PS=1.65U PD=1.65U
* device instance $16 r0 *1 7.725,2 NMOS_VTG
M$16 8 7 8 8 NMOS_VTG L=0.05U W=0.5U AS=0.375P AD=0.35P PS=3.75U PD=3.3U
* device instance $17 r0 *1 9.175,2 NMOS_VTG
M$17 7 4 8 8 NMOS_VTG L=0.05U W=0.25U AS=0.175P AD=0.2P PS=1.65U PD=2.1U
* device instance $19 r0 *1 3.375,3.05 NMOS_VTG
M$19 5 2 8 8 NMOS_VTG L=0.05U W=0.25U AS=0.175P AD=0.175P PS=1.65U PD=1.65U
* device instance $20 r0 *1 4.825,3.05 NMOS_VTG
M$20 6 8 5 8 NMOS_VTG L=0.05U W=0.25U AS=0.175P AD=0.175P PS=1.65U PD=1.65U
* device instance $21 r0 *1 6.275,3.05 NMOS_VTG
M$21 8 8 6 8 NMOS_VTG L=0.05U W=0.25U AS=0.175P AD=0.175P PS=1.65U PD=1.65U
* device instance $22 r0 *1 7.725,3.05 NMOS_VTG
M$22 8 5 8 8 NMOS_VTG L=0.05U W=0.25U AS=0.175P AD=0.2P PS=1.65U PD=2.1U
.ENDS DFF_V2_COMPACT_FEOL_BEOL_DP1p45_S7p1_RP0p3
