* cell DFF_V2_COMPACT_FEOL_BEOL_DP1p45_S7p25_RP0p3
* pin CLK
* pin D
* pin Q
* pin VDD
* pin VSS
.SUBCKT DFF_V2_COMPACT_FEOL_BEOL_DP1p45_S7p25_RP0p3 3 4 11 12 13
* net 3 CLK
* net 4 D
* net 11 Q
* net 12 VDD
* net 13 VSS
* device instance $1 r0 *1 1.925,7 PMOS_VTG
M$1 12 3 1 12 PMOS_VTG L=0.05U W=0.5U AS=0.4P AD=0.35P PS=2.6U PD=1.9U
* device instance $2 r0 *1 3.375,7 PMOS_VTG
M$2 5 4 12 12 PMOS_VTG L=0.05U W=0.5U AS=0.35P AD=0.35P PS=1.9U PD=1.9U
* device instance $3 r0 *1 4.825,7 PMOS_VTG
M$3 6 3 5 12 PMOS_VTG L=0.05U W=0.5U AS=0.35P AD=0.35P PS=1.9U PD=1.9U
* device instance $4 r0 *1 6.275,7 PMOS_VTG
M$4 2 1 6 12 PMOS_VTG L=0.05U W=0.5U AS=0.35P AD=0.35P PS=1.9U PD=1.9U
* device instance $5 r0 *1 7.725,7 PMOS_VTG
M$5 12 10 2 12 PMOS_VTG L=0.05U W=0.5U AS=0.35P AD=0.35P PS=1.9U PD=1.9U
* device instance $6 r0 *1 9.175,7 PMOS_VTG
M$6 10 6 12 12 PMOS_VTG L=0.05U W=0.5U AS=0.35P AD=0.4P PS=1.9U PD=2.6U
* device instance $7 r0 *1 1.925,5.75 PMOS_VTG
M$7 7 10 12 12 PMOS_VTG L=0.05U W=0.5U AS=0.4P AD=0.35P PS=2.6U PD=1.9U
* device instance $8 r0 *1 3.375,5.75 PMOS_VTG
M$8 8 1 7 12 PMOS_VTG L=0.05U W=0.5U AS=0.35P AD=0.35P PS=1.9U PD=1.9U
* device instance $9 r0 *1 4.825,5.75 PMOS_VTG
M$9 9 3 8 12 PMOS_VTG L=0.05U W=0.5U AS=0.35P AD=0.35P PS=1.9U PD=1.9U
* device instance $10 r0 *1 6.275,5.75 PMOS_VTG
M$10 12 11 9 12 PMOS_VTG L=0.05U W=0.5U AS=0.35P AD=0.35P PS=1.9U PD=1.9U
* device instance $11 r0 *1 7.725,5.75 PMOS_VTG
M$11 11 8 12 12 PMOS_VTG L=0.05U W=0.5U AS=0.35P AD=0.4P PS=1.9U PD=2.6U
* device instance $12 r0 *1 1.925,2 NMOS_VTG
M$12 13 3 1 13 NMOS_VTG L=0.05U W=0.25U AS=0.2P AD=0.175P PS=2.1U PD=1.65U
* device instance $13 r0 *1 3.375,2 NMOS_VTG
M$13 5 4 13 13 NMOS_VTG L=0.05U W=0.25U AS=0.175P AD=0.175P PS=1.65U PD=1.65U
* device instance $14 r0 *1 4.825,2 NMOS_VTG
M$14 6 1 5 13 NMOS_VTG L=0.05U W=0.25U AS=0.175P AD=0.175P PS=1.65U PD=1.65U
* device instance $15 r0 *1 6.275,2 NMOS_VTG
M$15 2 3 6 13 NMOS_VTG L=0.05U W=0.25U AS=0.175P AD=0.175P PS=1.65U PD=1.65U
* device instance $16 r0 *1 7.725,2 NMOS_VTG
M$16 13 10 2 13 NMOS_VTG L=0.05U W=0.25U AS=0.175P AD=0.175P PS=1.65U PD=1.65U
* device instance $17 r0 *1 9.175,2 NMOS_VTG
M$17 10 6 13 13 NMOS_VTG L=0.05U W=0.25U AS=0.175P AD=0.2P PS=1.65U PD=2.1U
* device instance $18 r0 *1 1.925,3.05 NMOS_VTG
M$18 7 10 13 13 NMOS_VTG L=0.05U W=0.25U AS=0.2P AD=0.175P PS=2.1U PD=1.65U
* device instance $19 r0 *1 3.375,3.05 NMOS_VTG
M$19 8 3 7 13 NMOS_VTG L=0.05U W=0.25U AS=0.175P AD=0.175P PS=1.65U PD=1.65U
* device instance $20 r0 *1 4.825,3.05 NMOS_VTG
M$20 9 1 8 13 NMOS_VTG L=0.05U W=0.25U AS=0.175P AD=0.175P PS=1.65U PD=1.65U
* device instance $21 r0 *1 6.275,3.05 NMOS_VTG
M$21 13 11 9 13 NMOS_VTG L=0.05U W=0.25U AS=0.175P AD=0.175P PS=1.65U PD=1.65U
* device instance $22 r0 *1 7.725,3.05 NMOS_VTG
M$22 11 8 13 13 NMOS_VTG L=0.05U W=0.25U AS=0.175P AD=0.2P PS=1.65U PD=2.1U
.ENDS DFF_V2_COMPACT_FEOL_BEOL_DP1p45_S7p25_RP0p3
