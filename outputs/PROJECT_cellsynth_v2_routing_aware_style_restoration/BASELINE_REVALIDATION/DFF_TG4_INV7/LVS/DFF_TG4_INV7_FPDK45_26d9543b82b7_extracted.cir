* cell DFF_TG4_INV7_FPDK45_26d9543b82b7
* pin D
* pin Q
* pin CLK
* pin VDD
* pin VSS
.SUBCKT DFF_TG4_INV7_FPDK45_26d9543b82b7 2 9 11 12 13
* net 2 D
* net 9 Q
* net 11 CLK
* net 12 VDD
* net 13 VSS
* device instance $1 r0 *1 9.02,0.3275 NMOS_VTG
M$1 8 11 7 13 NMOS_VTG L=0.05U W=0.25U AS=0.031875P AD=0.031875P PS=0.755U
+ PD=0.755U
* device instance $2 r0 *1 12.7625,0.3275 NMOS_VTG
M$2 8 1 10 13 NMOS_VTG L=0.05U W=0.25U AS=0.031875P AD=0.031875P PS=0.755U
+ PD=0.755U
* device instance $3 r0 *1 2.7825,0.3275 NMOS_VTG
M$3 4 1 3 13 NMOS_VTG L=0.05U W=0.25U AS=0.031875P AD=0.031875P PS=0.755U
+ PD=0.755U
* device instance $4 r0 *1 6.525,0.3275 NMOS_VTG
M$4 4 11 6 13 NMOS_VTG L=0.05U W=0.25U AS=0.031875P AD=0.031875P PS=0.755U
+ PD=0.755U
* device instance $5 r0 *1 9.02,1.4325 PMOS_VTG
M$5 8 1 7 12 PMOS_VTG L=0.05U W=0.5U AS=0.06375P AD=0.06375P PS=1.255U PD=1.255U
* device instance $6 r0 *1 12.7625,1.4325 PMOS_VTG
M$6 8 11 10 12 PMOS_VTG L=0.05U W=0.5U AS=0.06375P AD=0.06375P PS=1.255U
+ PD=1.255U
* device instance $7 r0 *1 2.7825,1.4325 PMOS_VTG
M$7 4 11 3 12 PMOS_VTG L=0.05U W=0.5U AS=0.06375P AD=0.06375P PS=1.255U
+ PD=1.255U
* device instance $8 r0 *1 6.525,1.4325 PMOS_VTG
M$8 4 1 6 12 PMOS_VTG L=0.05U W=0.5U AS=0.06375P AD=0.06375P PS=1.255U PD=1.255U
* device instance $9 r0 *1 0.2875,0.2825 NMOS_VTG
M$9 1 11 13 13 NMOS_VTG L=0.05U W=0.25U AS=0.031875P AD=0.031875P PS=0.755U
+ PD=0.755U
* device instance $10 r0 *1 1.535,0.2825 NMOS_VTG
M$10 3 2 13 13 NMOS_VTG L=0.05U W=0.25U AS=0.031875P AD=0.031875P PS=0.755U
+ PD=0.755U
* device instance $11 r0 *1 4.03,0.2825 NMOS_VTG
M$11 5 4 13 13 NMOS_VTG L=0.05U W=0.25U AS=0.031875P AD=0.031875P PS=0.755U
+ PD=0.755U
* device instance $12 r0 *1 7.7725,0.2825 NMOS_VTG
M$12 7 5 13 13 NMOS_VTG L=0.05U W=0.25U AS=0.031875P AD=0.031875P PS=0.755U
+ PD=0.755U
* device instance $13 r0 *1 5.2775,0.2825 NMOS_VTG
M$13 6 5 13 13 NMOS_VTG L=0.05U W=0.25U AS=0.031875P AD=0.031875P PS=0.755U
+ PD=0.755U
* device instance $14 r0 *1 10.2675,0.2825 NMOS_VTG
M$14 9 8 13 13 NMOS_VTG L=0.05U W=0.25U AS=0.031875P AD=0.031875P PS=0.755U
+ PD=0.755U
* device instance $15 r0 *1 11.515,0.2825 NMOS_VTG
M$15 10 9 13 13 NMOS_VTG L=0.05U W=0.25U AS=0.031875P AD=0.031875P PS=0.755U
+ PD=0.755U
* device instance $16 r0 *1 0.2875,1.4775 PMOS_VTG
M$16 1 11 12 12 PMOS_VTG L=0.05U W=0.5U AS=0.06375P AD=0.06375P PS=1.255U
+ PD=1.255U
* device instance $17 r0 *1 1.535,1.4775 PMOS_VTG
M$17 3 2 12 12 PMOS_VTG L=0.05U W=0.5U AS=0.06375P AD=0.06375P PS=1.255U
+ PD=1.255U
* device instance $18 r0 *1 4.03,1.4775 PMOS_VTG
M$18 5 4 12 12 PMOS_VTG L=0.05U W=0.5U AS=0.06375P AD=0.06375P PS=1.255U
+ PD=1.255U
* device instance $19 r0 *1 7.7725,1.4775 PMOS_VTG
M$19 7 5 12 12 PMOS_VTG L=0.05U W=0.5U AS=0.06375P AD=0.06375P PS=1.255U
+ PD=1.255U
* device instance $20 r0 *1 5.2775,1.4775 PMOS_VTG
M$20 6 5 12 12 PMOS_VTG L=0.05U W=0.5U AS=0.06375P AD=0.06375P PS=1.255U
+ PD=1.255U
* device instance $21 r0 *1 10.2675,1.4775 PMOS_VTG
M$21 9 8 12 12 PMOS_VTG L=0.05U W=0.5U AS=0.06375P AD=0.06375P PS=1.255U
+ PD=1.255U
* device instance $22 r0 *1 11.515,1.4775 PMOS_VTG
M$22 10 9 12 12 PMOS_VTG L=0.05U W=0.5U AS=0.06375P AD=0.06375P PS=1.255U
+ PD=1.255U
.ENDS DFF_TG4_INV7_FPDK45_26d9543b82b7
