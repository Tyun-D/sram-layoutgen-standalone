* cell DFF_9P1_REPAIR_ITER010
* pin CLK
* pin D
* pin Q
* pin VDD
* pin VSS
.SUBCKT DFF_9P1_REPAIR_ITER010 1 3 4 12 13
* net 1 CLK
* net 3 D
* net 4 Q
* net 12 VDD
* net 13 VSS
* device instance $1 r0 *1 0.4375,1.73 PMOS_VTG
M$1 12 7 4 12 PMOS_VTG L=0.05U W=0.5U AS=0.12625P AD=0.038125P PS=1.505U
+ PD=0.6525U
* device instance $2 r0 *1 0.64,1.73 PMOS_VTG
M$2 8 4 12 12 PMOS_VTG L=0.05U W=0.5U AS=0.038125P AD=0.0375P PS=0.6525U
+ PD=0.65U
* device instance $3 r0 *1 0.84,1.73 PMOS_VTG
M$3 7 1 8 12 PMOS_VTG L=0.05U W=0.5U AS=0.0375P AD=0.038125P PS=0.65U PD=0.6525U
* device instance $4 r0 *1 1.0425,1.73 PMOS_VTG
M$4 9 2 7 12 PMOS_VTG L=0.05U W=0.5U AS=0.038125P AD=0.038125P PS=0.6525U
+ PD=0.6525U
* device instance $5 r0 *1 1.245,1.73 PMOS_VTG
M$5 12 6 9 12 PMOS_VTG L=0.05U W=0.5U AS=0.038125P AD=0.038125P PS=0.6525U
+ PD=0.6525U
* device instance $6 r0 *1 1.4475,1.73 PMOS_VTG
M$6 10 6 12 12 PMOS_VTG L=0.05U W=0.5U AS=0.038125P AD=0.038125P PS=0.6525U
+ PD=0.6525U
* device instance $7 r0 *1 1.65,1.73 PMOS_VTG
M$7 5 2 10 12 PMOS_VTG L=0.05U W=0.5U AS=0.038125P AD=0.0375P PS=0.6525U
+ PD=0.65U
* device instance $8 r0 *1 1.85,1.73 PMOS_VTG
M$8 11 1 5 12 PMOS_VTG L=0.05U W=0.5U AS=0.0375P AD=0.038125P PS=0.65U
+ PD=0.6525U
* device instance $9 r0 *1 2.0525,1.73 PMOS_VTG
M$9 12 3 11 12 PMOS_VTG L=0.05U W=0.5U AS=0.038125P AD=0.038125P PS=0.6525U
+ PD=0.6525U
* device instance $10 r0 *1 2.255,1.73 PMOS_VTG
M$10 6 5 12 12 PMOS_VTG L=0.05U W=0.5U AS=0.038125P AD=0.12625P PS=0.6525U
+ PD=1.505U
* device instance $11 r0 *1 2.935,1.73 PMOS_VTG
M$11 12 1 2 12 PMOS_VTG L=0.05U W=0.5U AS=0.12625P AD=0.125P PS=1.505U PD=1.5U
* device instance $12 r0 *1 2.935,0.605 NMOS_VTG
M$12 13 1 2 13 NMOS_VTG L=0.05U W=0.25U AS=0.063125P AD=0.0625P PS=1.005U PD=1U
* device instance $13 r0 *1 0.4375,0.605 NMOS_VTG
M$13 13 7 4 13 NMOS_VTG L=0.05U W=0.25U AS=0.063125P AD=0.0190625P PS=1.005U
+ PD=0.4025U
* device instance $14 r0 *1 0.64,0.605 NMOS_VTG
M$14 8 4 13 13 NMOS_VTG L=0.05U W=0.25U AS=0.0190625P AD=0.01875P PS=0.4025U
+ PD=0.4U
* device instance $15 r0 *1 0.84,0.605 NMOS_VTG
M$15 7 2 8 13 NMOS_VTG L=0.05U W=0.25U AS=0.01875P AD=0.0190625P PS=0.4U
+ PD=0.4025U
* device instance $16 r0 *1 1.0425,0.605 NMOS_VTG
M$16 9 1 7 13 NMOS_VTG L=0.05U W=0.25U AS=0.0190625P AD=0.0190625P PS=0.4025U
+ PD=0.4025U
* device instance $17 r0 *1 1.245,0.605 NMOS_VTG
M$17 13 6 9 13 NMOS_VTG L=0.05U W=0.25U AS=0.0190625P AD=0.0190625P PS=0.4025U
+ PD=0.4025U
* device instance $18 r0 *1 1.4475,0.605 NMOS_VTG
M$18 10 6 13 13 NMOS_VTG L=0.05U W=0.25U AS=0.0190625P AD=0.0190625P PS=0.4025U
+ PD=0.4025U
* device instance $19 r0 *1 1.65,0.605 NMOS_VTG
M$19 5 1 10 13 NMOS_VTG L=0.05U W=0.25U AS=0.0190625P AD=0.01875P PS=0.4025U
+ PD=0.4U
* device instance $20 r0 *1 1.85,0.605 NMOS_VTG
M$20 11 2 5 13 NMOS_VTG L=0.05U W=0.25U AS=0.01875P AD=0.0190625P PS=0.4U
+ PD=0.4025U
* device instance $21 r0 *1 2.0525,0.605 NMOS_VTG
M$21 13 3 11 13 NMOS_VTG L=0.05U W=0.25U AS=0.0190625P AD=0.0190625P PS=0.4025U
+ PD=0.4025U
* device instance $22 r0 *1 2.255,0.605 NMOS_VTG
M$22 6 5 13 13 NMOS_VTG L=0.05U W=0.25U AS=0.0190625P AD=0.063125P PS=0.4025U
+ PD=1.005U
.ENDS DFF_9P1_REPAIR_ITER010
