.title SRAM_6T_CORE_64x8_TB
* Clean layout-facing extraction generated from sram_compiler/testbenches/sram_6t_core_testbench.py::Sram6TCoreTestbench.create_testbench
* Source testbench netlist: outputs/M12N_lock_openyield_authoritative_netlist/current_supported_config/sample_openyield_sram_netlist.sp
.include /data1/qujh/work/external/OpenYield/tran_models/models_TT.spice

.subckt SRAM_6T_CORE_64x8 VDD VSS BL0 BL1 BL2 BL3 BL4 BL5 BL6 BL7 BLB0 BLB1 BLB2 BLB3 BLB4 BLB5 BLB6 BLB7 WL0 WL1 WL2 WL3 WL4 WL5 WL6 WL7 WL8 WL9 WL10 WL11 WL12 WL13 WL14 WL15 WL16 WL17 WL18 WL19 WL20 WL21 WL22 WL23 WL24 WL25 WL26 WL27 WL28 WL29 WL30 WL31 WL32 WL33 WL34 WL35 WL36 WL37 WL38 WL39 WL40 WL41 WL42 WL43 WL44 WL45 WL46 WL47 WL48 WL49 WL50 WL51 WL52 WL53 WL54 WL55 WL56 WL57 WL58 WL59 WL60 WL61 WL62 WL63
XSRAM_6T_CELL_0_0 VDD VSS BL0 BLB0 WL0 SRAM_6T_CELL
XSRAM_6T_CELL_0_1 VDD VSS BL1 BLB1 WL0 SRAM_6T_CELL
XSRAM_6T_CELL_0_2 VDD VSS BL2 BLB2 WL0 SRAM_6T_CELL
XSRAM_6T_CELL_0_3 VDD VSS BL3 BLB3 WL0 SRAM_6T_CELL
XSRAM_6T_CELL_0_4 VDD VSS BL4 BLB4 WL0 SRAM_6T_CELL
XSRAM_6T_CELL_0_5 VDD VSS BL5 BLB5 WL0 SRAM_6T_CELL
XSRAM_6T_CELL_0_6 VDD VSS BL6 BLB6 WL0 SRAM_6T_CELL
XSRAM_6T_CELL_0_7 VDD VSS BL7 BLB7 WL0 SRAM_6T_CELL
XSRAM_6T_CELL_1_0 VDD VSS BL0 BLB0 WL1 SRAM_6T_CELL
XSRAM_6T_CELL_1_1 VDD VSS BL1 BLB1 WL1 SRAM_6T_CELL
XSRAM_6T_CELL_1_2 VDD VSS BL2 BLB2 WL1 SRAM_6T_CELL
XSRAM_6T_CELL_1_3 VDD VSS BL3 BLB3 WL1 SRAM_6T_CELL
XSRAM_6T_CELL_1_4 VDD VSS BL4 BLB4 WL1 SRAM_6T_CELL
XSRAM_6T_CELL_1_5 VDD VSS BL5 BLB5 WL1 SRAM_6T_CELL
XSRAM_6T_CELL_1_6 VDD VSS BL6 BLB6 WL1 SRAM_6T_CELL
XSRAM_6T_CELL_1_7 VDD VSS BL7 BLB7 WL1 SRAM_6T_CELL
XSRAM_6T_CELL_2_0 VDD VSS BL0 BLB0 WL2 SRAM_6T_CELL
XSRAM_6T_CELL_2_1 VDD VSS BL1 BLB1 WL2 SRAM_6T_CELL
XSRAM_6T_CELL_2_2 VDD VSS BL2 BLB2 WL2 SRAM_6T_CELL
XSRAM_6T_CELL_2_3 VDD VSS BL3 BLB3 WL2 SRAM_6T_CELL
XSRAM_6T_CELL_2_4 VDD VSS BL4 BLB4 WL2 SRAM_6T_CELL
XSRAM_6T_CELL_2_5 VDD VSS BL5 BLB5 WL2 SRAM_6T_CELL
XSRAM_6T_CELL_2_6 VDD VSS BL6 BLB6 WL2 SRAM_6T_CELL
XSRAM_6T_CELL_2_7 VDD VSS BL7 BLB7 WL2 SRAM_6T_CELL
XSRAM_6T_CELL_3_0 VDD VSS BL0 BLB0 WL3 SRAM_6T_CELL
XSRAM_6T_CELL_3_1 VDD VSS BL1 BLB1 WL3 SRAM_6T_CELL
XSRAM_6T_CELL_3_2 VDD VSS BL2 BLB2 WL3 SRAM_6T_CELL
XSRAM_6T_CELL_3_3 VDD VSS BL3 BLB3 WL3 SRAM_6T_CELL
XSRAM_6T_CELL_3_4 VDD VSS BL4 BLB4 WL3 SRAM_6T_CELL
XSRAM_6T_CELL_3_5 VDD VSS BL5 BLB5 WL3 SRAM_6T_CELL
XSRAM_6T_CELL_3_6 VDD VSS BL6 BLB6 WL3 SRAM_6T_CELL
XSRAM_6T_CELL_3_7 VDD VSS BL7 BLB7 WL3 SRAM_6T_CELL
XSRAM_6T_CELL_4_0 VDD VSS BL0 BLB0 WL4 SRAM_6T_CELL
XSRAM_6T_CELL_4_1 VDD VSS BL1 BLB1 WL4 SRAM_6T_CELL
XSRAM_6T_CELL_4_2 VDD VSS BL2 BLB2 WL4 SRAM_6T_CELL
XSRAM_6T_CELL_4_3 VDD VSS BL3 BLB3 WL4 SRAM_6T_CELL
XSRAM_6T_CELL_4_4 VDD VSS BL4 BLB4 WL4 SRAM_6T_CELL
XSRAM_6T_CELL_4_5 VDD VSS BL5 BLB5 WL4 SRAM_6T_CELL
XSRAM_6T_CELL_4_6 VDD VSS BL6 BLB6 WL4 SRAM_6T_CELL
XSRAM_6T_CELL_4_7 VDD VSS BL7 BLB7 WL4 SRAM_6T_CELL
XSRAM_6T_CELL_5_0 VDD VSS BL0 BLB0 WL5 SRAM_6T_CELL
XSRAM_6T_CELL_5_1 VDD VSS BL1 BLB1 WL5 SRAM_6T_CELL
XSRAM_6T_CELL_5_2 VDD VSS BL2 BLB2 WL5 SRAM_6T_CELL
XSRAM_6T_CELL_5_3 VDD VSS BL3 BLB3 WL5 SRAM_6T_CELL
XSRAM_6T_CELL_5_4 VDD VSS BL4 BLB4 WL5 SRAM_6T_CELL
XSRAM_6T_CELL_5_5 VDD VSS BL5 BLB5 WL5 SRAM_6T_CELL
XSRAM_6T_CELL_5_6 VDD VSS BL6 BLB6 WL5 SRAM_6T_CELL
XSRAM_6T_CELL_5_7 VDD VSS BL7 BLB7 WL5 SRAM_6T_CELL
XSRAM_6T_CELL_6_0 VDD VSS BL0 BLB0 WL6 SRAM_6T_CELL
XSRAM_6T_CELL_6_1 VDD VSS BL1 BLB1 WL6 SRAM_6T_CELL
XSRAM_6T_CELL_6_2 VDD VSS BL2 BLB2 WL6 SRAM_6T_CELL
XSRAM_6T_CELL_6_3 VDD VSS BL3 BLB3 WL6 SRAM_6T_CELL
XSRAM_6T_CELL_6_4 VDD VSS BL4 BLB4 WL6 SRAM_6T_CELL
XSRAM_6T_CELL_6_5 VDD VSS BL5 BLB5 WL6 SRAM_6T_CELL
XSRAM_6T_CELL_6_6 VDD VSS BL6 BLB6 WL6 SRAM_6T_CELL
XSRAM_6T_CELL_6_7 VDD VSS BL7 BLB7 WL6 SRAM_6T_CELL
XSRAM_6T_CELL_7_0 VDD VSS BL0 BLB0 WL7 SRAM_6T_CELL
XSRAM_6T_CELL_7_1 VDD VSS BL1 BLB1 WL7 SRAM_6T_CELL
XSRAM_6T_CELL_7_2 VDD VSS BL2 BLB2 WL7 SRAM_6T_CELL
XSRAM_6T_CELL_7_3 VDD VSS BL3 BLB3 WL7 SRAM_6T_CELL
XSRAM_6T_CELL_7_4 VDD VSS BL4 BLB4 WL7 SRAM_6T_CELL
XSRAM_6T_CELL_7_5 VDD VSS BL5 BLB5 WL7 SRAM_6T_CELL
XSRAM_6T_CELL_7_6 VDD VSS BL6 BLB6 WL7 SRAM_6T_CELL
XSRAM_6T_CELL_7_7 VDD VSS BL7 BLB7 WL7 SRAM_6T_CELL
XSRAM_6T_CELL_8_0 VDD VSS BL0 BLB0 WL8 SRAM_6T_CELL
XSRAM_6T_CELL_8_1 VDD VSS BL1 BLB1 WL8 SRAM_6T_CELL
XSRAM_6T_CELL_8_2 VDD VSS BL2 BLB2 WL8 SRAM_6T_CELL
XSRAM_6T_CELL_8_3 VDD VSS BL3 BLB3 WL8 SRAM_6T_CELL
XSRAM_6T_CELL_8_4 VDD VSS BL4 BLB4 WL8 SRAM_6T_CELL
XSRAM_6T_CELL_8_5 VDD VSS BL5 BLB5 WL8 SRAM_6T_CELL
XSRAM_6T_CELL_8_6 VDD VSS BL6 BLB6 WL8 SRAM_6T_CELL
XSRAM_6T_CELL_8_7 VDD VSS BL7 BLB7 WL8 SRAM_6T_CELL
XSRAM_6T_CELL_9_0 VDD VSS BL0 BLB0 WL9 SRAM_6T_CELL
XSRAM_6T_CELL_9_1 VDD VSS BL1 BLB1 WL9 SRAM_6T_CELL
XSRAM_6T_CELL_9_2 VDD VSS BL2 BLB2 WL9 SRAM_6T_CELL
XSRAM_6T_CELL_9_3 VDD VSS BL3 BLB3 WL9 SRAM_6T_CELL
XSRAM_6T_CELL_9_4 VDD VSS BL4 BLB4 WL9 SRAM_6T_CELL
XSRAM_6T_CELL_9_5 VDD VSS BL5 BLB5 WL9 SRAM_6T_CELL
XSRAM_6T_CELL_9_6 VDD VSS BL6 BLB6 WL9 SRAM_6T_CELL
XSRAM_6T_CELL_9_7 VDD VSS BL7 BLB7 WL9 SRAM_6T_CELL
XSRAM_6T_CELL_10_0 VDD VSS BL0 BLB0 WL10 SRAM_6T_CELL
XSRAM_6T_CELL_10_1 VDD VSS BL1 BLB1 WL10 SRAM_6T_CELL
XSRAM_6T_CELL_10_2 VDD VSS BL2 BLB2 WL10 SRAM_6T_CELL
XSRAM_6T_CELL_10_3 VDD VSS BL3 BLB3 WL10 SRAM_6T_CELL
XSRAM_6T_CELL_10_4 VDD VSS BL4 BLB4 WL10 SRAM_6T_CELL
XSRAM_6T_CELL_10_5 VDD VSS BL5 BLB5 WL10 SRAM_6T_CELL
XSRAM_6T_CELL_10_6 VDD VSS BL6 BLB6 WL10 SRAM_6T_CELL
XSRAM_6T_CELL_10_7 VDD VSS BL7 BLB7 WL10 SRAM_6T_CELL
XSRAM_6T_CELL_11_0 VDD VSS BL0 BLB0 WL11 SRAM_6T_CELL
XSRAM_6T_CELL_11_1 VDD VSS BL1 BLB1 WL11 SRAM_6T_CELL
XSRAM_6T_CELL_11_2 VDD VSS BL2 BLB2 WL11 SRAM_6T_CELL
XSRAM_6T_CELL_11_3 VDD VSS BL3 BLB3 WL11 SRAM_6T_CELL
XSRAM_6T_CELL_11_4 VDD VSS BL4 BLB4 WL11 SRAM_6T_CELL
XSRAM_6T_CELL_11_5 VDD VSS BL5 BLB5 WL11 SRAM_6T_CELL
XSRAM_6T_CELL_11_6 VDD VSS BL6 BLB6 WL11 SRAM_6T_CELL
XSRAM_6T_CELL_11_7 VDD VSS BL7 BLB7 WL11 SRAM_6T_CELL
XSRAM_6T_CELL_12_0 VDD VSS BL0 BLB0 WL12 SRAM_6T_CELL
XSRAM_6T_CELL_12_1 VDD VSS BL1 BLB1 WL12 SRAM_6T_CELL
XSRAM_6T_CELL_12_2 VDD VSS BL2 BLB2 WL12 SRAM_6T_CELL
XSRAM_6T_CELL_12_3 VDD VSS BL3 BLB3 WL12 SRAM_6T_CELL
XSRAM_6T_CELL_12_4 VDD VSS BL4 BLB4 WL12 SRAM_6T_CELL
XSRAM_6T_CELL_12_5 VDD VSS BL5 BLB5 WL12 SRAM_6T_CELL
XSRAM_6T_CELL_12_6 VDD VSS BL6 BLB6 WL12 SRAM_6T_CELL
XSRAM_6T_CELL_12_7 VDD VSS BL7 BLB7 WL12 SRAM_6T_CELL
XSRAM_6T_CELL_13_0 VDD VSS BL0 BLB0 WL13 SRAM_6T_CELL
XSRAM_6T_CELL_13_1 VDD VSS BL1 BLB1 WL13 SRAM_6T_CELL
XSRAM_6T_CELL_13_2 VDD VSS BL2 BLB2 WL13 SRAM_6T_CELL
XSRAM_6T_CELL_13_3 VDD VSS BL3 BLB3 WL13 SRAM_6T_CELL
XSRAM_6T_CELL_13_4 VDD VSS BL4 BLB4 WL13 SRAM_6T_CELL
XSRAM_6T_CELL_13_5 VDD VSS BL5 BLB5 WL13 SRAM_6T_CELL
XSRAM_6T_CELL_13_6 VDD VSS BL6 BLB6 WL13 SRAM_6T_CELL
XSRAM_6T_CELL_13_7 VDD VSS BL7 BLB7 WL13 SRAM_6T_CELL
XSRAM_6T_CELL_14_0 VDD VSS BL0 BLB0 WL14 SRAM_6T_CELL
XSRAM_6T_CELL_14_1 VDD VSS BL1 BLB1 WL14 SRAM_6T_CELL
XSRAM_6T_CELL_14_2 VDD VSS BL2 BLB2 WL14 SRAM_6T_CELL
XSRAM_6T_CELL_14_3 VDD VSS BL3 BLB3 WL14 SRAM_6T_CELL
XSRAM_6T_CELL_14_4 VDD VSS BL4 BLB4 WL14 SRAM_6T_CELL
XSRAM_6T_CELL_14_5 VDD VSS BL5 BLB5 WL14 SRAM_6T_CELL
XSRAM_6T_CELL_14_6 VDD VSS BL6 BLB6 WL14 SRAM_6T_CELL
XSRAM_6T_CELL_14_7 VDD VSS BL7 BLB7 WL14 SRAM_6T_CELL
XSRAM_6T_CELL_15_0 VDD VSS BL0 BLB0 WL15 SRAM_6T_CELL
XSRAM_6T_CELL_15_1 VDD VSS BL1 BLB1 WL15 SRAM_6T_CELL
XSRAM_6T_CELL_15_2 VDD VSS BL2 BLB2 WL15 SRAM_6T_CELL
XSRAM_6T_CELL_15_3 VDD VSS BL3 BLB3 WL15 SRAM_6T_CELL
XSRAM_6T_CELL_15_4 VDD VSS BL4 BLB4 WL15 SRAM_6T_CELL
XSRAM_6T_CELL_15_5 VDD VSS BL5 BLB5 WL15 SRAM_6T_CELL
XSRAM_6T_CELL_15_6 VDD VSS BL6 BLB6 WL15 SRAM_6T_CELL
XSRAM_6T_CELL_15_7 VDD VSS BL7 BLB7 WL15 SRAM_6T_CELL
XSRAM_6T_CELL_16_0 VDD VSS BL0 BLB0 WL16 SRAM_6T_CELL
XSRAM_6T_CELL_16_1 VDD VSS BL1 BLB1 WL16 SRAM_6T_CELL
XSRAM_6T_CELL_16_2 VDD VSS BL2 BLB2 WL16 SRAM_6T_CELL
XSRAM_6T_CELL_16_3 VDD VSS BL3 BLB3 WL16 SRAM_6T_CELL
XSRAM_6T_CELL_16_4 VDD VSS BL4 BLB4 WL16 SRAM_6T_CELL
XSRAM_6T_CELL_16_5 VDD VSS BL5 BLB5 WL16 SRAM_6T_CELL
XSRAM_6T_CELL_16_6 VDD VSS BL6 BLB6 WL16 SRAM_6T_CELL
XSRAM_6T_CELL_16_7 VDD VSS BL7 BLB7 WL16 SRAM_6T_CELL
XSRAM_6T_CELL_17_0 VDD VSS BL0 BLB0 WL17 SRAM_6T_CELL
XSRAM_6T_CELL_17_1 VDD VSS BL1 BLB1 WL17 SRAM_6T_CELL
XSRAM_6T_CELL_17_2 VDD VSS BL2 BLB2 WL17 SRAM_6T_CELL
XSRAM_6T_CELL_17_3 VDD VSS BL3 BLB3 WL17 SRAM_6T_CELL
XSRAM_6T_CELL_17_4 VDD VSS BL4 BLB4 WL17 SRAM_6T_CELL
XSRAM_6T_CELL_17_5 VDD VSS BL5 BLB5 WL17 SRAM_6T_CELL
XSRAM_6T_CELL_17_6 VDD VSS BL6 BLB6 WL17 SRAM_6T_CELL
XSRAM_6T_CELL_17_7 VDD VSS BL7 BLB7 WL17 SRAM_6T_CELL
XSRAM_6T_CELL_18_0 VDD VSS BL0 BLB0 WL18 SRAM_6T_CELL
XSRAM_6T_CELL_18_1 VDD VSS BL1 BLB1 WL18 SRAM_6T_CELL
XSRAM_6T_CELL_18_2 VDD VSS BL2 BLB2 WL18 SRAM_6T_CELL
XSRAM_6T_CELL_18_3 VDD VSS BL3 BLB3 WL18 SRAM_6T_CELL
XSRAM_6T_CELL_18_4 VDD VSS BL4 BLB4 WL18 SRAM_6T_CELL
XSRAM_6T_CELL_18_5 VDD VSS BL5 BLB5 WL18 SRAM_6T_CELL
XSRAM_6T_CELL_18_6 VDD VSS BL6 BLB6 WL18 SRAM_6T_CELL
XSRAM_6T_CELL_18_7 VDD VSS BL7 BLB7 WL18 SRAM_6T_CELL
XSRAM_6T_CELL_19_0 VDD VSS BL0 BLB0 WL19 SRAM_6T_CELL
XSRAM_6T_CELL_19_1 VDD VSS BL1 BLB1 WL19 SRAM_6T_CELL
XSRAM_6T_CELL_19_2 VDD VSS BL2 BLB2 WL19 SRAM_6T_CELL
XSRAM_6T_CELL_19_3 VDD VSS BL3 BLB3 WL19 SRAM_6T_CELL
XSRAM_6T_CELL_19_4 VDD VSS BL4 BLB4 WL19 SRAM_6T_CELL
XSRAM_6T_CELL_19_5 VDD VSS BL5 BLB5 WL19 SRAM_6T_CELL
XSRAM_6T_CELL_19_6 VDD VSS BL6 BLB6 WL19 SRAM_6T_CELL
XSRAM_6T_CELL_19_7 VDD VSS BL7 BLB7 WL19 SRAM_6T_CELL
XSRAM_6T_CELL_20_0 VDD VSS BL0 BLB0 WL20 SRAM_6T_CELL
XSRAM_6T_CELL_20_1 VDD VSS BL1 BLB1 WL20 SRAM_6T_CELL
XSRAM_6T_CELL_20_2 VDD VSS BL2 BLB2 WL20 SRAM_6T_CELL
XSRAM_6T_CELL_20_3 VDD VSS BL3 BLB3 WL20 SRAM_6T_CELL
XSRAM_6T_CELL_20_4 VDD VSS BL4 BLB4 WL20 SRAM_6T_CELL
XSRAM_6T_CELL_20_5 VDD VSS BL5 BLB5 WL20 SRAM_6T_CELL
XSRAM_6T_CELL_20_6 VDD VSS BL6 BLB6 WL20 SRAM_6T_CELL
XSRAM_6T_CELL_20_7 VDD VSS BL7 BLB7 WL20 SRAM_6T_CELL
XSRAM_6T_CELL_21_0 VDD VSS BL0 BLB0 WL21 SRAM_6T_CELL
XSRAM_6T_CELL_21_1 VDD VSS BL1 BLB1 WL21 SRAM_6T_CELL
XSRAM_6T_CELL_21_2 VDD VSS BL2 BLB2 WL21 SRAM_6T_CELL
XSRAM_6T_CELL_21_3 VDD VSS BL3 BLB3 WL21 SRAM_6T_CELL
XSRAM_6T_CELL_21_4 VDD VSS BL4 BLB4 WL21 SRAM_6T_CELL
XSRAM_6T_CELL_21_5 VDD VSS BL5 BLB5 WL21 SRAM_6T_CELL
XSRAM_6T_CELL_21_6 VDD VSS BL6 BLB6 WL21 SRAM_6T_CELL
XSRAM_6T_CELL_21_7 VDD VSS BL7 BLB7 WL21 SRAM_6T_CELL
XSRAM_6T_CELL_22_0 VDD VSS BL0 BLB0 WL22 SRAM_6T_CELL
XSRAM_6T_CELL_22_1 VDD VSS BL1 BLB1 WL22 SRAM_6T_CELL
XSRAM_6T_CELL_22_2 VDD VSS BL2 BLB2 WL22 SRAM_6T_CELL
XSRAM_6T_CELL_22_3 VDD VSS BL3 BLB3 WL22 SRAM_6T_CELL
XSRAM_6T_CELL_22_4 VDD VSS BL4 BLB4 WL22 SRAM_6T_CELL
XSRAM_6T_CELL_22_5 VDD VSS BL5 BLB5 WL22 SRAM_6T_CELL
XSRAM_6T_CELL_22_6 VDD VSS BL6 BLB6 WL22 SRAM_6T_CELL
XSRAM_6T_CELL_22_7 VDD VSS BL7 BLB7 WL22 SRAM_6T_CELL
XSRAM_6T_CELL_23_0 VDD VSS BL0 BLB0 WL23 SRAM_6T_CELL
XSRAM_6T_CELL_23_1 VDD VSS BL1 BLB1 WL23 SRAM_6T_CELL
XSRAM_6T_CELL_23_2 VDD VSS BL2 BLB2 WL23 SRAM_6T_CELL
XSRAM_6T_CELL_23_3 VDD VSS BL3 BLB3 WL23 SRAM_6T_CELL
XSRAM_6T_CELL_23_4 VDD VSS BL4 BLB4 WL23 SRAM_6T_CELL
XSRAM_6T_CELL_23_5 VDD VSS BL5 BLB5 WL23 SRAM_6T_CELL
XSRAM_6T_CELL_23_6 VDD VSS BL6 BLB6 WL23 SRAM_6T_CELL
XSRAM_6T_CELL_23_7 VDD VSS BL7 BLB7 WL23 SRAM_6T_CELL
XSRAM_6T_CELL_24_0 VDD VSS BL0 BLB0 WL24 SRAM_6T_CELL
XSRAM_6T_CELL_24_1 VDD VSS BL1 BLB1 WL24 SRAM_6T_CELL
XSRAM_6T_CELL_24_2 VDD VSS BL2 BLB2 WL24 SRAM_6T_CELL
XSRAM_6T_CELL_24_3 VDD VSS BL3 BLB3 WL24 SRAM_6T_CELL
XSRAM_6T_CELL_24_4 VDD VSS BL4 BLB4 WL24 SRAM_6T_CELL
XSRAM_6T_CELL_24_5 VDD VSS BL5 BLB5 WL24 SRAM_6T_CELL
XSRAM_6T_CELL_24_6 VDD VSS BL6 BLB6 WL24 SRAM_6T_CELL
XSRAM_6T_CELL_24_7 VDD VSS BL7 BLB7 WL24 SRAM_6T_CELL
XSRAM_6T_CELL_25_0 VDD VSS BL0 BLB0 WL25 SRAM_6T_CELL
XSRAM_6T_CELL_25_1 VDD VSS BL1 BLB1 WL25 SRAM_6T_CELL
XSRAM_6T_CELL_25_2 VDD VSS BL2 BLB2 WL25 SRAM_6T_CELL
XSRAM_6T_CELL_25_3 VDD VSS BL3 BLB3 WL25 SRAM_6T_CELL
XSRAM_6T_CELL_25_4 VDD VSS BL4 BLB4 WL25 SRAM_6T_CELL
XSRAM_6T_CELL_25_5 VDD VSS BL5 BLB5 WL25 SRAM_6T_CELL
XSRAM_6T_CELL_25_6 VDD VSS BL6 BLB6 WL25 SRAM_6T_CELL
XSRAM_6T_CELL_25_7 VDD VSS BL7 BLB7 WL25 SRAM_6T_CELL
XSRAM_6T_CELL_26_0 VDD VSS BL0 BLB0 WL26 SRAM_6T_CELL
XSRAM_6T_CELL_26_1 VDD VSS BL1 BLB1 WL26 SRAM_6T_CELL
XSRAM_6T_CELL_26_2 VDD VSS BL2 BLB2 WL26 SRAM_6T_CELL
XSRAM_6T_CELL_26_3 VDD VSS BL3 BLB3 WL26 SRAM_6T_CELL
XSRAM_6T_CELL_26_4 VDD VSS BL4 BLB4 WL26 SRAM_6T_CELL
XSRAM_6T_CELL_26_5 VDD VSS BL5 BLB5 WL26 SRAM_6T_CELL
XSRAM_6T_CELL_26_6 VDD VSS BL6 BLB6 WL26 SRAM_6T_CELL
XSRAM_6T_CELL_26_7 VDD VSS BL7 BLB7 WL26 SRAM_6T_CELL
XSRAM_6T_CELL_27_0 VDD VSS BL0 BLB0 WL27 SRAM_6T_CELL
XSRAM_6T_CELL_27_1 VDD VSS BL1 BLB1 WL27 SRAM_6T_CELL
XSRAM_6T_CELL_27_2 VDD VSS BL2 BLB2 WL27 SRAM_6T_CELL
XSRAM_6T_CELL_27_3 VDD VSS BL3 BLB3 WL27 SRAM_6T_CELL
XSRAM_6T_CELL_27_4 VDD VSS BL4 BLB4 WL27 SRAM_6T_CELL
XSRAM_6T_CELL_27_5 VDD VSS BL5 BLB5 WL27 SRAM_6T_CELL
XSRAM_6T_CELL_27_6 VDD VSS BL6 BLB6 WL27 SRAM_6T_CELL
XSRAM_6T_CELL_27_7 VDD VSS BL7 BLB7 WL27 SRAM_6T_CELL
XSRAM_6T_CELL_28_0 VDD VSS BL0 BLB0 WL28 SRAM_6T_CELL
XSRAM_6T_CELL_28_1 VDD VSS BL1 BLB1 WL28 SRAM_6T_CELL
XSRAM_6T_CELL_28_2 VDD VSS BL2 BLB2 WL28 SRAM_6T_CELL
XSRAM_6T_CELL_28_3 VDD VSS BL3 BLB3 WL28 SRAM_6T_CELL
XSRAM_6T_CELL_28_4 VDD VSS BL4 BLB4 WL28 SRAM_6T_CELL
XSRAM_6T_CELL_28_5 VDD VSS BL5 BLB5 WL28 SRAM_6T_CELL
XSRAM_6T_CELL_28_6 VDD VSS BL6 BLB6 WL28 SRAM_6T_CELL
XSRAM_6T_CELL_28_7 VDD VSS BL7 BLB7 WL28 SRAM_6T_CELL
XSRAM_6T_CELL_29_0 VDD VSS BL0 BLB0 WL29 SRAM_6T_CELL
XSRAM_6T_CELL_29_1 VDD VSS BL1 BLB1 WL29 SRAM_6T_CELL
XSRAM_6T_CELL_29_2 VDD VSS BL2 BLB2 WL29 SRAM_6T_CELL
XSRAM_6T_CELL_29_3 VDD VSS BL3 BLB3 WL29 SRAM_6T_CELL
XSRAM_6T_CELL_29_4 VDD VSS BL4 BLB4 WL29 SRAM_6T_CELL
XSRAM_6T_CELL_29_5 VDD VSS BL5 BLB5 WL29 SRAM_6T_CELL
XSRAM_6T_CELL_29_6 VDD VSS BL6 BLB6 WL29 SRAM_6T_CELL
XSRAM_6T_CELL_29_7 VDD VSS BL7 BLB7 WL29 SRAM_6T_CELL
XSRAM_6T_CELL_30_0 VDD VSS BL0 BLB0 WL30 SRAM_6T_CELL
XSRAM_6T_CELL_30_1 VDD VSS BL1 BLB1 WL30 SRAM_6T_CELL
XSRAM_6T_CELL_30_2 VDD VSS BL2 BLB2 WL30 SRAM_6T_CELL
XSRAM_6T_CELL_30_3 VDD VSS BL3 BLB3 WL30 SRAM_6T_CELL
XSRAM_6T_CELL_30_4 VDD VSS BL4 BLB4 WL30 SRAM_6T_CELL
XSRAM_6T_CELL_30_5 VDD VSS BL5 BLB5 WL30 SRAM_6T_CELL
XSRAM_6T_CELL_30_6 VDD VSS BL6 BLB6 WL30 SRAM_6T_CELL
XSRAM_6T_CELL_30_7 VDD VSS BL7 BLB7 WL30 SRAM_6T_CELL
XSRAM_6T_CELL_31_0 VDD VSS BL0 BLB0 WL31 SRAM_6T_CELL
XSRAM_6T_CELL_31_1 VDD VSS BL1 BLB1 WL31 SRAM_6T_CELL
XSRAM_6T_CELL_31_2 VDD VSS BL2 BLB2 WL31 SRAM_6T_CELL
XSRAM_6T_CELL_31_3 VDD VSS BL3 BLB3 WL31 SRAM_6T_CELL
XSRAM_6T_CELL_31_4 VDD VSS BL4 BLB4 WL31 SRAM_6T_CELL
XSRAM_6T_CELL_31_5 VDD VSS BL5 BLB5 WL31 SRAM_6T_CELL
XSRAM_6T_CELL_31_6 VDD VSS BL6 BLB6 WL31 SRAM_6T_CELL
XSRAM_6T_CELL_31_7 VDD VSS BL7 BLB7 WL31 SRAM_6T_CELL
XSRAM_6T_CELL_32_0 VDD VSS BL0 BLB0 WL32 SRAM_6T_CELL
XSRAM_6T_CELL_32_1 VDD VSS BL1 BLB1 WL32 SRAM_6T_CELL
XSRAM_6T_CELL_32_2 VDD VSS BL2 BLB2 WL32 SRAM_6T_CELL
XSRAM_6T_CELL_32_3 VDD VSS BL3 BLB3 WL32 SRAM_6T_CELL
XSRAM_6T_CELL_32_4 VDD VSS BL4 BLB4 WL32 SRAM_6T_CELL
XSRAM_6T_CELL_32_5 VDD VSS BL5 BLB5 WL32 SRAM_6T_CELL
XSRAM_6T_CELL_32_6 VDD VSS BL6 BLB6 WL32 SRAM_6T_CELL
XSRAM_6T_CELL_32_7 VDD VSS BL7 BLB7 WL32 SRAM_6T_CELL
XSRAM_6T_CELL_33_0 VDD VSS BL0 BLB0 WL33 SRAM_6T_CELL
XSRAM_6T_CELL_33_1 VDD VSS BL1 BLB1 WL33 SRAM_6T_CELL
XSRAM_6T_CELL_33_2 VDD VSS BL2 BLB2 WL33 SRAM_6T_CELL
XSRAM_6T_CELL_33_3 VDD VSS BL3 BLB3 WL33 SRAM_6T_CELL
XSRAM_6T_CELL_33_4 VDD VSS BL4 BLB4 WL33 SRAM_6T_CELL
XSRAM_6T_CELL_33_5 VDD VSS BL5 BLB5 WL33 SRAM_6T_CELL
XSRAM_6T_CELL_33_6 VDD VSS BL6 BLB6 WL33 SRAM_6T_CELL
XSRAM_6T_CELL_33_7 VDD VSS BL7 BLB7 WL33 SRAM_6T_CELL
XSRAM_6T_CELL_34_0 VDD VSS BL0 BLB0 WL34 SRAM_6T_CELL
XSRAM_6T_CELL_34_1 VDD VSS BL1 BLB1 WL34 SRAM_6T_CELL
XSRAM_6T_CELL_34_2 VDD VSS BL2 BLB2 WL34 SRAM_6T_CELL
XSRAM_6T_CELL_34_3 VDD VSS BL3 BLB3 WL34 SRAM_6T_CELL
XSRAM_6T_CELL_34_4 VDD VSS BL4 BLB4 WL34 SRAM_6T_CELL
XSRAM_6T_CELL_34_5 VDD VSS BL5 BLB5 WL34 SRAM_6T_CELL
XSRAM_6T_CELL_34_6 VDD VSS BL6 BLB6 WL34 SRAM_6T_CELL
XSRAM_6T_CELL_34_7 VDD VSS BL7 BLB7 WL34 SRAM_6T_CELL
XSRAM_6T_CELL_35_0 VDD VSS BL0 BLB0 WL35 SRAM_6T_CELL
XSRAM_6T_CELL_35_1 VDD VSS BL1 BLB1 WL35 SRAM_6T_CELL
XSRAM_6T_CELL_35_2 VDD VSS BL2 BLB2 WL35 SRAM_6T_CELL
XSRAM_6T_CELL_35_3 VDD VSS BL3 BLB3 WL35 SRAM_6T_CELL
XSRAM_6T_CELL_35_4 VDD VSS BL4 BLB4 WL35 SRAM_6T_CELL
XSRAM_6T_CELL_35_5 VDD VSS BL5 BLB5 WL35 SRAM_6T_CELL
XSRAM_6T_CELL_35_6 VDD VSS BL6 BLB6 WL35 SRAM_6T_CELL
XSRAM_6T_CELL_35_7 VDD VSS BL7 BLB7 WL35 SRAM_6T_CELL
XSRAM_6T_CELL_36_0 VDD VSS BL0 BLB0 WL36 SRAM_6T_CELL
XSRAM_6T_CELL_36_1 VDD VSS BL1 BLB1 WL36 SRAM_6T_CELL
XSRAM_6T_CELL_36_2 VDD VSS BL2 BLB2 WL36 SRAM_6T_CELL
XSRAM_6T_CELL_36_3 VDD VSS BL3 BLB3 WL36 SRAM_6T_CELL
XSRAM_6T_CELL_36_4 VDD VSS BL4 BLB4 WL36 SRAM_6T_CELL
XSRAM_6T_CELL_36_5 VDD VSS BL5 BLB5 WL36 SRAM_6T_CELL
XSRAM_6T_CELL_36_6 VDD VSS BL6 BLB6 WL36 SRAM_6T_CELL
XSRAM_6T_CELL_36_7 VDD VSS BL7 BLB7 WL36 SRAM_6T_CELL
XSRAM_6T_CELL_37_0 VDD VSS BL0 BLB0 WL37 SRAM_6T_CELL
XSRAM_6T_CELL_37_1 VDD VSS BL1 BLB1 WL37 SRAM_6T_CELL
XSRAM_6T_CELL_37_2 VDD VSS BL2 BLB2 WL37 SRAM_6T_CELL
XSRAM_6T_CELL_37_3 VDD VSS BL3 BLB3 WL37 SRAM_6T_CELL
XSRAM_6T_CELL_37_4 VDD VSS BL4 BLB4 WL37 SRAM_6T_CELL
XSRAM_6T_CELL_37_5 VDD VSS BL5 BLB5 WL37 SRAM_6T_CELL
XSRAM_6T_CELL_37_6 VDD VSS BL6 BLB6 WL37 SRAM_6T_CELL
XSRAM_6T_CELL_37_7 VDD VSS BL7 BLB7 WL37 SRAM_6T_CELL
XSRAM_6T_CELL_38_0 VDD VSS BL0 BLB0 WL38 SRAM_6T_CELL
XSRAM_6T_CELL_38_1 VDD VSS BL1 BLB1 WL38 SRAM_6T_CELL
XSRAM_6T_CELL_38_2 VDD VSS BL2 BLB2 WL38 SRAM_6T_CELL
XSRAM_6T_CELL_38_3 VDD VSS BL3 BLB3 WL38 SRAM_6T_CELL
XSRAM_6T_CELL_38_4 VDD VSS BL4 BLB4 WL38 SRAM_6T_CELL
XSRAM_6T_CELL_38_5 VDD VSS BL5 BLB5 WL38 SRAM_6T_CELL
XSRAM_6T_CELL_38_6 VDD VSS BL6 BLB6 WL38 SRAM_6T_CELL
XSRAM_6T_CELL_38_7 VDD VSS BL7 BLB7 WL38 SRAM_6T_CELL
XSRAM_6T_CELL_39_0 VDD VSS BL0 BLB0 WL39 SRAM_6T_CELL
XSRAM_6T_CELL_39_1 VDD VSS BL1 BLB1 WL39 SRAM_6T_CELL
XSRAM_6T_CELL_39_2 VDD VSS BL2 BLB2 WL39 SRAM_6T_CELL
XSRAM_6T_CELL_39_3 VDD VSS BL3 BLB3 WL39 SRAM_6T_CELL
XSRAM_6T_CELL_39_4 VDD VSS BL4 BLB4 WL39 SRAM_6T_CELL
XSRAM_6T_CELL_39_5 VDD VSS BL5 BLB5 WL39 SRAM_6T_CELL
XSRAM_6T_CELL_39_6 VDD VSS BL6 BLB6 WL39 SRAM_6T_CELL
XSRAM_6T_CELL_39_7 VDD VSS BL7 BLB7 WL39 SRAM_6T_CELL
XSRAM_6T_CELL_40_0 VDD VSS BL0 BLB0 WL40 SRAM_6T_CELL
XSRAM_6T_CELL_40_1 VDD VSS BL1 BLB1 WL40 SRAM_6T_CELL
XSRAM_6T_CELL_40_2 VDD VSS BL2 BLB2 WL40 SRAM_6T_CELL
XSRAM_6T_CELL_40_3 VDD VSS BL3 BLB3 WL40 SRAM_6T_CELL
XSRAM_6T_CELL_40_4 VDD VSS BL4 BLB4 WL40 SRAM_6T_CELL
XSRAM_6T_CELL_40_5 VDD VSS BL5 BLB5 WL40 SRAM_6T_CELL
XSRAM_6T_CELL_40_6 VDD VSS BL6 BLB6 WL40 SRAM_6T_CELL
XSRAM_6T_CELL_40_7 VDD VSS BL7 BLB7 WL40 SRAM_6T_CELL
XSRAM_6T_CELL_41_0 VDD VSS BL0 BLB0 WL41 SRAM_6T_CELL
XSRAM_6T_CELL_41_1 VDD VSS BL1 BLB1 WL41 SRAM_6T_CELL
XSRAM_6T_CELL_41_2 VDD VSS BL2 BLB2 WL41 SRAM_6T_CELL
XSRAM_6T_CELL_41_3 VDD VSS BL3 BLB3 WL41 SRAM_6T_CELL
XSRAM_6T_CELL_41_4 VDD VSS BL4 BLB4 WL41 SRAM_6T_CELL
XSRAM_6T_CELL_41_5 VDD VSS BL5 BLB5 WL41 SRAM_6T_CELL
XSRAM_6T_CELL_41_6 VDD VSS BL6 BLB6 WL41 SRAM_6T_CELL
XSRAM_6T_CELL_41_7 VDD VSS BL7 BLB7 WL41 SRAM_6T_CELL
XSRAM_6T_CELL_42_0 VDD VSS BL0 BLB0 WL42 SRAM_6T_CELL
XSRAM_6T_CELL_42_1 VDD VSS BL1 BLB1 WL42 SRAM_6T_CELL
XSRAM_6T_CELL_42_2 VDD VSS BL2 BLB2 WL42 SRAM_6T_CELL
XSRAM_6T_CELL_42_3 VDD VSS BL3 BLB3 WL42 SRAM_6T_CELL
XSRAM_6T_CELL_42_4 VDD VSS BL4 BLB4 WL42 SRAM_6T_CELL
XSRAM_6T_CELL_42_5 VDD VSS BL5 BLB5 WL42 SRAM_6T_CELL
XSRAM_6T_CELL_42_6 VDD VSS BL6 BLB6 WL42 SRAM_6T_CELL
XSRAM_6T_CELL_42_7 VDD VSS BL7 BLB7 WL42 SRAM_6T_CELL
XSRAM_6T_CELL_43_0 VDD VSS BL0 BLB0 WL43 SRAM_6T_CELL
XSRAM_6T_CELL_43_1 VDD VSS BL1 BLB1 WL43 SRAM_6T_CELL
XSRAM_6T_CELL_43_2 VDD VSS BL2 BLB2 WL43 SRAM_6T_CELL
XSRAM_6T_CELL_43_3 VDD VSS BL3 BLB3 WL43 SRAM_6T_CELL
XSRAM_6T_CELL_43_4 VDD VSS BL4 BLB4 WL43 SRAM_6T_CELL
XSRAM_6T_CELL_43_5 VDD VSS BL5 BLB5 WL43 SRAM_6T_CELL
XSRAM_6T_CELL_43_6 VDD VSS BL6 BLB6 WL43 SRAM_6T_CELL
XSRAM_6T_CELL_43_7 VDD VSS BL7 BLB7 WL43 SRAM_6T_CELL
XSRAM_6T_CELL_44_0 VDD VSS BL0 BLB0 WL44 SRAM_6T_CELL
XSRAM_6T_CELL_44_1 VDD VSS BL1 BLB1 WL44 SRAM_6T_CELL
XSRAM_6T_CELL_44_2 VDD VSS BL2 BLB2 WL44 SRAM_6T_CELL
XSRAM_6T_CELL_44_3 VDD VSS BL3 BLB3 WL44 SRAM_6T_CELL
XSRAM_6T_CELL_44_4 VDD VSS BL4 BLB4 WL44 SRAM_6T_CELL
XSRAM_6T_CELL_44_5 VDD VSS BL5 BLB5 WL44 SRAM_6T_CELL
XSRAM_6T_CELL_44_6 VDD VSS BL6 BLB6 WL44 SRAM_6T_CELL
XSRAM_6T_CELL_44_7 VDD VSS BL7 BLB7 WL44 SRAM_6T_CELL
XSRAM_6T_CELL_45_0 VDD VSS BL0 BLB0 WL45 SRAM_6T_CELL
XSRAM_6T_CELL_45_1 VDD VSS BL1 BLB1 WL45 SRAM_6T_CELL
XSRAM_6T_CELL_45_2 VDD VSS BL2 BLB2 WL45 SRAM_6T_CELL
XSRAM_6T_CELL_45_3 VDD VSS BL3 BLB3 WL45 SRAM_6T_CELL
XSRAM_6T_CELL_45_4 VDD VSS BL4 BLB4 WL45 SRAM_6T_CELL
XSRAM_6T_CELL_45_5 VDD VSS BL5 BLB5 WL45 SRAM_6T_CELL
XSRAM_6T_CELL_45_6 VDD VSS BL6 BLB6 WL45 SRAM_6T_CELL
XSRAM_6T_CELL_45_7 VDD VSS BL7 BLB7 WL45 SRAM_6T_CELL
XSRAM_6T_CELL_46_0 VDD VSS BL0 BLB0 WL46 SRAM_6T_CELL
XSRAM_6T_CELL_46_1 VDD VSS BL1 BLB1 WL46 SRAM_6T_CELL
XSRAM_6T_CELL_46_2 VDD VSS BL2 BLB2 WL46 SRAM_6T_CELL
XSRAM_6T_CELL_46_3 VDD VSS BL3 BLB3 WL46 SRAM_6T_CELL
XSRAM_6T_CELL_46_4 VDD VSS BL4 BLB4 WL46 SRAM_6T_CELL
XSRAM_6T_CELL_46_5 VDD VSS BL5 BLB5 WL46 SRAM_6T_CELL
XSRAM_6T_CELL_46_6 VDD VSS BL6 BLB6 WL46 SRAM_6T_CELL
XSRAM_6T_CELL_46_7 VDD VSS BL7 BLB7 WL46 SRAM_6T_CELL
XSRAM_6T_CELL_47_0 VDD VSS BL0 BLB0 WL47 SRAM_6T_CELL
XSRAM_6T_CELL_47_1 VDD VSS BL1 BLB1 WL47 SRAM_6T_CELL
XSRAM_6T_CELL_47_2 VDD VSS BL2 BLB2 WL47 SRAM_6T_CELL
XSRAM_6T_CELL_47_3 VDD VSS BL3 BLB3 WL47 SRAM_6T_CELL
XSRAM_6T_CELL_47_4 VDD VSS BL4 BLB4 WL47 SRAM_6T_CELL
XSRAM_6T_CELL_47_5 VDD VSS BL5 BLB5 WL47 SRAM_6T_CELL
XSRAM_6T_CELL_47_6 VDD VSS BL6 BLB6 WL47 SRAM_6T_CELL
XSRAM_6T_CELL_47_7 VDD VSS BL7 BLB7 WL47 SRAM_6T_CELL
XSRAM_6T_CELL_48_0 VDD VSS BL0 BLB0 WL48 SRAM_6T_CELL
XSRAM_6T_CELL_48_1 VDD VSS BL1 BLB1 WL48 SRAM_6T_CELL
XSRAM_6T_CELL_48_2 VDD VSS BL2 BLB2 WL48 SRAM_6T_CELL
XSRAM_6T_CELL_48_3 VDD VSS BL3 BLB3 WL48 SRAM_6T_CELL
XSRAM_6T_CELL_48_4 VDD VSS BL4 BLB4 WL48 SRAM_6T_CELL
XSRAM_6T_CELL_48_5 VDD VSS BL5 BLB5 WL48 SRAM_6T_CELL
XSRAM_6T_CELL_48_6 VDD VSS BL6 BLB6 WL48 SRAM_6T_CELL
XSRAM_6T_CELL_48_7 VDD VSS BL7 BLB7 WL48 SRAM_6T_CELL
XSRAM_6T_CELL_49_0 VDD VSS BL0 BLB0 WL49 SRAM_6T_CELL
XSRAM_6T_CELL_49_1 VDD VSS BL1 BLB1 WL49 SRAM_6T_CELL
XSRAM_6T_CELL_49_2 VDD VSS BL2 BLB2 WL49 SRAM_6T_CELL
XSRAM_6T_CELL_49_3 VDD VSS BL3 BLB3 WL49 SRAM_6T_CELL
XSRAM_6T_CELL_49_4 VDD VSS BL4 BLB4 WL49 SRAM_6T_CELL
XSRAM_6T_CELL_49_5 VDD VSS BL5 BLB5 WL49 SRAM_6T_CELL
XSRAM_6T_CELL_49_6 VDD VSS BL6 BLB6 WL49 SRAM_6T_CELL
XSRAM_6T_CELL_49_7 VDD VSS BL7 BLB7 WL49 SRAM_6T_CELL
XSRAM_6T_CELL_50_0 VDD VSS BL0 BLB0 WL50 SRAM_6T_CELL
XSRAM_6T_CELL_50_1 VDD VSS BL1 BLB1 WL50 SRAM_6T_CELL
XSRAM_6T_CELL_50_2 VDD VSS BL2 BLB2 WL50 SRAM_6T_CELL
XSRAM_6T_CELL_50_3 VDD VSS BL3 BLB3 WL50 SRAM_6T_CELL
XSRAM_6T_CELL_50_4 VDD VSS BL4 BLB4 WL50 SRAM_6T_CELL
XSRAM_6T_CELL_50_5 VDD VSS BL5 BLB5 WL50 SRAM_6T_CELL
XSRAM_6T_CELL_50_6 VDD VSS BL6 BLB6 WL50 SRAM_6T_CELL
XSRAM_6T_CELL_50_7 VDD VSS BL7 BLB7 WL50 SRAM_6T_CELL
XSRAM_6T_CELL_51_0 VDD VSS BL0 BLB0 WL51 SRAM_6T_CELL
XSRAM_6T_CELL_51_1 VDD VSS BL1 BLB1 WL51 SRAM_6T_CELL
XSRAM_6T_CELL_51_2 VDD VSS BL2 BLB2 WL51 SRAM_6T_CELL
XSRAM_6T_CELL_51_3 VDD VSS BL3 BLB3 WL51 SRAM_6T_CELL
XSRAM_6T_CELL_51_4 VDD VSS BL4 BLB4 WL51 SRAM_6T_CELL
XSRAM_6T_CELL_51_5 VDD VSS BL5 BLB5 WL51 SRAM_6T_CELL
XSRAM_6T_CELL_51_6 VDD VSS BL6 BLB6 WL51 SRAM_6T_CELL
XSRAM_6T_CELL_51_7 VDD VSS BL7 BLB7 WL51 SRAM_6T_CELL
XSRAM_6T_CELL_52_0 VDD VSS BL0 BLB0 WL52 SRAM_6T_CELL
XSRAM_6T_CELL_52_1 VDD VSS BL1 BLB1 WL52 SRAM_6T_CELL
XSRAM_6T_CELL_52_2 VDD VSS BL2 BLB2 WL52 SRAM_6T_CELL
XSRAM_6T_CELL_52_3 VDD VSS BL3 BLB3 WL52 SRAM_6T_CELL
XSRAM_6T_CELL_52_4 VDD VSS BL4 BLB4 WL52 SRAM_6T_CELL
XSRAM_6T_CELL_52_5 VDD VSS BL5 BLB5 WL52 SRAM_6T_CELL
XSRAM_6T_CELL_52_6 VDD VSS BL6 BLB6 WL52 SRAM_6T_CELL
XSRAM_6T_CELL_52_7 VDD VSS BL7 BLB7 WL52 SRAM_6T_CELL
XSRAM_6T_CELL_53_0 VDD VSS BL0 BLB0 WL53 SRAM_6T_CELL
XSRAM_6T_CELL_53_1 VDD VSS BL1 BLB1 WL53 SRAM_6T_CELL
XSRAM_6T_CELL_53_2 VDD VSS BL2 BLB2 WL53 SRAM_6T_CELL
XSRAM_6T_CELL_53_3 VDD VSS BL3 BLB3 WL53 SRAM_6T_CELL
XSRAM_6T_CELL_53_4 VDD VSS BL4 BLB4 WL53 SRAM_6T_CELL
XSRAM_6T_CELL_53_5 VDD VSS BL5 BLB5 WL53 SRAM_6T_CELL
XSRAM_6T_CELL_53_6 VDD VSS BL6 BLB6 WL53 SRAM_6T_CELL
XSRAM_6T_CELL_53_7 VDD VSS BL7 BLB7 WL53 SRAM_6T_CELL
XSRAM_6T_CELL_54_0 VDD VSS BL0 BLB0 WL54 SRAM_6T_CELL
XSRAM_6T_CELL_54_1 VDD VSS BL1 BLB1 WL54 SRAM_6T_CELL
XSRAM_6T_CELL_54_2 VDD VSS BL2 BLB2 WL54 SRAM_6T_CELL
XSRAM_6T_CELL_54_3 VDD VSS BL3 BLB3 WL54 SRAM_6T_CELL
XSRAM_6T_CELL_54_4 VDD VSS BL4 BLB4 WL54 SRAM_6T_CELL
XSRAM_6T_CELL_54_5 VDD VSS BL5 BLB5 WL54 SRAM_6T_CELL
XSRAM_6T_CELL_54_6 VDD VSS BL6 BLB6 WL54 SRAM_6T_CELL
XSRAM_6T_CELL_54_7 VDD VSS BL7 BLB7 WL54 SRAM_6T_CELL
XSRAM_6T_CELL_55_0 VDD VSS BL0 BLB0 WL55 SRAM_6T_CELL
XSRAM_6T_CELL_55_1 VDD VSS BL1 BLB1 WL55 SRAM_6T_CELL
XSRAM_6T_CELL_55_2 VDD VSS BL2 BLB2 WL55 SRAM_6T_CELL
XSRAM_6T_CELL_55_3 VDD VSS BL3 BLB3 WL55 SRAM_6T_CELL
XSRAM_6T_CELL_55_4 VDD VSS BL4 BLB4 WL55 SRAM_6T_CELL
XSRAM_6T_CELL_55_5 VDD VSS BL5 BLB5 WL55 SRAM_6T_CELL
XSRAM_6T_CELL_55_6 VDD VSS BL6 BLB6 WL55 SRAM_6T_CELL
XSRAM_6T_CELL_55_7 VDD VSS BL7 BLB7 WL55 SRAM_6T_CELL
XSRAM_6T_CELL_56_0 VDD VSS BL0 BLB0 WL56 SRAM_6T_CELL
XSRAM_6T_CELL_56_1 VDD VSS BL1 BLB1 WL56 SRAM_6T_CELL
XSRAM_6T_CELL_56_2 VDD VSS BL2 BLB2 WL56 SRAM_6T_CELL
XSRAM_6T_CELL_56_3 VDD VSS BL3 BLB3 WL56 SRAM_6T_CELL
XSRAM_6T_CELL_56_4 VDD VSS BL4 BLB4 WL56 SRAM_6T_CELL
XSRAM_6T_CELL_56_5 VDD VSS BL5 BLB5 WL56 SRAM_6T_CELL
XSRAM_6T_CELL_56_6 VDD VSS BL6 BLB6 WL56 SRAM_6T_CELL
XSRAM_6T_CELL_56_7 VDD VSS BL7 BLB7 WL56 SRAM_6T_CELL
XSRAM_6T_CELL_57_0 VDD VSS BL0 BLB0 WL57 SRAM_6T_CELL
XSRAM_6T_CELL_57_1 VDD VSS BL1 BLB1 WL57 SRAM_6T_CELL
XSRAM_6T_CELL_57_2 VDD VSS BL2 BLB2 WL57 SRAM_6T_CELL
XSRAM_6T_CELL_57_3 VDD VSS BL3 BLB3 WL57 SRAM_6T_CELL
XSRAM_6T_CELL_57_4 VDD VSS BL4 BLB4 WL57 SRAM_6T_CELL
XSRAM_6T_CELL_57_5 VDD VSS BL5 BLB5 WL57 SRAM_6T_CELL
XSRAM_6T_CELL_57_6 VDD VSS BL6 BLB6 WL57 SRAM_6T_CELL
XSRAM_6T_CELL_57_7 VDD VSS BL7 BLB7 WL57 SRAM_6T_CELL
XSRAM_6T_CELL_58_0 VDD VSS BL0 BLB0 WL58 SRAM_6T_CELL
XSRAM_6T_CELL_58_1 VDD VSS BL1 BLB1 WL58 SRAM_6T_CELL
XSRAM_6T_CELL_58_2 VDD VSS BL2 BLB2 WL58 SRAM_6T_CELL
XSRAM_6T_CELL_58_3 VDD VSS BL3 BLB3 WL58 SRAM_6T_CELL
XSRAM_6T_CELL_58_4 VDD VSS BL4 BLB4 WL58 SRAM_6T_CELL
XSRAM_6T_CELL_58_5 VDD VSS BL5 BLB5 WL58 SRAM_6T_CELL
XSRAM_6T_CELL_58_6 VDD VSS BL6 BLB6 WL58 SRAM_6T_CELL
XSRAM_6T_CELL_58_7 VDD VSS BL7 BLB7 WL58 SRAM_6T_CELL
XSRAM_6T_CELL_59_0 VDD VSS BL0 BLB0 WL59 SRAM_6T_CELL
XSRAM_6T_CELL_59_1 VDD VSS BL1 BLB1 WL59 SRAM_6T_CELL
XSRAM_6T_CELL_59_2 VDD VSS BL2 BLB2 WL59 SRAM_6T_CELL
XSRAM_6T_CELL_59_3 VDD VSS BL3 BLB3 WL59 SRAM_6T_CELL
XSRAM_6T_CELL_59_4 VDD VSS BL4 BLB4 WL59 SRAM_6T_CELL
XSRAM_6T_CELL_59_5 VDD VSS BL5 BLB5 WL59 SRAM_6T_CELL
XSRAM_6T_CELL_59_6 VDD VSS BL6 BLB6 WL59 SRAM_6T_CELL
XSRAM_6T_CELL_59_7 VDD VSS BL7 BLB7 WL59 SRAM_6T_CELL
XSRAM_6T_CELL_60_0 VDD VSS BL0 BLB0 WL60 SRAM_6T_CELL
XSRAM_6T_CELL_60_1 VDD VSS BL1 BLB1 WL60 SRAM_6T_CELL
XSRAM_6T_CELL_60_2 VDD VSS BL2 BLB2 WL60 SRAM_6T_CELL
XSRAM_6T_CELL_60_3 VDD VSS BL3 BLB3 WL60 SRAM_6T_CELL
XSRAM_6T_CELL_60_4 VDD VSS BL4 BLB4 WL60 SRAM_6T_CELL
XSRAM_6T_CELL_60_5 VDD VSS BL5 BLB5 WL60 SRAM_6T_CELL
XSRAM_6T_CELL_60_6 VDD VSS BL6 BLB6 WL60 SRAM_6T_CELL
XSRAM_6T_CELL_60_7 VDD VSS BL7 BLB7 WL60 SRAM_6T_CELL
XSRAM_6T_CELL_61_0 VDD VSS BL0 BLB0 WL61 SRAM_6T_CELL
XSRAM_6T_CELL_61_1 VDD VSS BL1 BLB1 WL61 SRAM_6T_CELL
XSRAM_6T_CELL_61_2 VDD VSS BL2 BLB2 WL61 SRAM_6T_CELL
XSRAM_6T_CELL_61_3 VDD VSS BL3 BLB3 WL61 SRAM_6T_CELL
XSRAM_6T_CELL_61_4 VDD VSS BL4 BLB4 WL61 SRAM_6T_CELL
XSRAM_6T_CELL_61_5 VDD VSS BL5 BLB5 WL61 SRAM_6T_CELL
XSRAM_6T_CELL_61_6 VDD VSS BL6 BLB6 WL61 SRAM_6T_CELL
XSRAM_6T_CELL_61_7 VDD VSS BL7 BLB7 WL61 SRAM_6T_CELL
XSRAM_6T_CELL_62_0 VDD VSS BL0 BLB0 WL62 SRAM_6T_CELL
XSRAM_6T_CELL_62_1 VDD VSS BL1 BLB1 WL62 SRAM_6T_CELL
XSRAM_6T_CELL_62_2 VDD VSS BL2 BLB2 WL62 SRAM_6T_CELL
XSRAM_6T_CELL_62_3 VDD VSS BL3 BLB3 WL62 SRAM_6T_CELL
XSRAM_6T_CELL_62_4 VDD VSS BL4 BLB4 WL62 SRAM_6T_CELL
XSRAM_6T_CELL_62_5 VDD VSS BL5 BLB5 WL62 SRAM_6T_CELL
XSRAM_6T_CELL_62_6 VDD VSS BL6 BLB6 WL62 SRAM_6T_CELL
XSRAM_6T_CELL_62_7 VDD VSS BL7 BLB7 WL62 SRAM_6T_CELL
XSRAM_6T_CELL_63_0 VDD VSS BL0 BLB0 WL63 SRAM_6T_CELL
XSRAM_6T_CELL_63_1 VDD VSS BL1 BLB1 WL63 SRAM_6T_CELL
XSRAM_6T_CELL_63_2 VDD VSS BL2 BLB2 WL63 SRAM_6T_CELL
XSRAM_6T_CELL_63_3 VDD VSS BL3 BLB3 WL63 SRAM_6T_CELL
XSRAM_6T_CELL_63_4 VDD VSS BL4 BLB4 WL63 SRAM_6T_CELL
XSRAM_6T_CELL_63_5 VDD VSS BL5 BLB5 WL63 SRAM_6T_CELL
XSRAM_6T_CELL_63_6 VDD VSS BL6 BLB6 WL63 SRAM_6T_CELL
XSRAM_6T_CELL_63_7 VDD VSS BL7 BLB7 WL63 SRAM_6T_CELL
.ends SRAM_6T_CORE_64x8

.subckt SRAM_6T_CELL VDD VSS BL BLB WL
MPGL BL WL Q VSS NMOS_VTG l=5e-08 w=1.35e-07
MPGR BLB WL QB VSS NMOS_VTG l=5e-08 w=1.35e-07
MPDL Q QB VSS VSS NMOS_VTG l=5e-08 w=2.05e-07
MPDR QB Q VSS VSS NMOS_VTG l=5e-08 w=2.05e-07
MPUL Q QB VDD VDD PMOS_VTG l=5e-08 w=9e-08
MPUR QB Q VDD VDD PMOS_VTG l=5e-08 w=9e-08
.ends SRAM_6T_CELL

.subckt sram_65x1_replica_column VDD VSS RBL RBLB WL0 WL1 WL2 WL3 WL4 WL5 WL6 WL7 WL8 WL9 WL10 WL11 WL12 WL13 WL14 WL15 WL16 WL17 WL18 WL19 WL20 WL21 WL22 WL23 WL24 WL25 WL26 WL27 WL28 WL29 WL30 WL31 WL32 WL33 WL34 WL35 WL36 WL37 WL38 WL39 WL40 WL41 WL42 WL43 WL44 WL45 WL46 WL47 WL48 WL49 WL50 WL51 WL52 WL53 WL54 WL55 WL56 WL57 WL58 WL59 WL60 WL61 WL62 WL63 WL64
XReplica_CELL_0 VDD VSS RBL RBLB WL0 Replica_CELL
XReplica_CELL_1 VDD VSS RBL RBLB WL1 Replica_CELL
XReplica_CELL_2 VDD VSS RBL RBLB WL2 Replica_CELL
XReplica_CELL_3 VDD VSS RBL RBLB WL3 Replica_CELL
XReplica_CELL_4 VDD VSS RBL RBLB WL4 Replica_CELL
XReplica_CELL_5 VDD VSS RBL RBLB WL5 Replica_CELL
XReplica_CELL_6 VDD VSS RBL RBLB WL6 Replica_CELL
XReplica_CELL_7 VDD VSS RBL RBLB WL7 Replica_CELL
XReplica_CELL_8 VDD VSS RBL RBLB WL8 Replica_CELL
XReplica_CELL_9 VDD VSS RBL RBLB WL9 Replica_CELL
XReplica_CELL_10 VDD VSS RBL RBLB WL10 Replica_CELL
XReplica_CELL_11 VDD VSS RBL RBLB WL11 Replica_CELL
XReplica_CELL_12 VDD VSS RBL RBLB WL12 Replica_CELL
XReplica_CELL_13 VDD VSS RBL RBLB WL13 Replica_CELL
XReplica_CELL_14 VDD VSS RBL RBLB WL14 Replica_CELL
XReplica_CELL_15 VDD VSS RBL RBLB WL15 Replica_CELL
XReplica_CELL_16 VDD VSS RBL RBLB WL16 Replica_CELL
XReplica_CELL_17 VDD VSS RBL RBLB WL17 Replica_CELL
XReplica_CELL_18 VDD VSS RBL RBLB WL18 Replica_CELL
XReplica_CELL_19 VDD VSS RBL RBLB WL19 Replica_CELL
XReplica_CELL_20 VDD VSS RBL RBLB WL20 Replica_CELL
XReplica_CELL_21 VDD VSS RBL RBLB WL21 Replica_CELL
XReplica_CELL_22 VDD VSS RBL RBLB WL22 Replica_CELL
XReplica_CELL_23 VDD VSS RBL RBLB WL23 Replica_CELL
XReplica_CELL_24 VDD VSS RBL RBLB WL24 Replica_CELL
XReplica_CELL_25 VDD VSS RBL RBLB WL25 Replica_CELL
XReplica_CELL_26 VDD VSS RBL RBLB WL26 Replica_CELL
XReplica_CELL_27 VDD VSS RBL RBLB WL27 Replica_CELL
XReplica_CELL_28 VDD VSS RBL RBLB WL28 Replica_CELL
XReplica_CELL_29 VDD VSS RBL RBLB WL29 Replica_CELL
XReplica_CELL_30 VDD VSS RBL RBLB WL30 Replica_CELL
XReplica_CELL_31 VDD VSS RBL RBLB WL31 Replica_CELL
XReplica_CELL_32 VDD VSS RBL RBLB WL32 Replica_CELL
XReplica_CELL_33 VDD VSS RBL RBLB WL33 Replica_CELL
XReplica_CELL_34 VDD VSS RBL RBLB WL34 Replica_CELL
XReplica_CELL_35 VDD VSS RBL RBLB WL35 Replica_CELL
XReplica_CELL_36 VDD VSS RBL RBLB WL36 Replica_CELL
XReplica_CELL_37 VDD VSS RBL RBLB WL37 Replica_CELL
XReplica_CELL_38 VDD VSS RBL RBLB WL38 Replica_CELL
XReplica_CELL_39 VDD VSS RBL RBLB WL39 Replica_CELL
XReplica_CELL_40 VDD VSS RBL RBLB WL40 Replica_CELL
XReplica_CELL_41 VDD VSS RBL RBLB WL41 Replica_CELL
XReplica_CELL_42 VDD VSS RBL RBLB WL42 Replica_CELL
XReplica_CELL_43 VDD VSS RBL RBLB WL43 Replica_CELL
XReplica_CELL_44 VDD VSS RBL RBLB WL44 Replica_CELL
XReplica_CELL_45 VDD VSS RBL RBLB WL45 Replica_CELL
XReplica_CELL_46 VDD VSS RBL RBLB WL46 Replica_CELL
XReplica_CELL_47 VDD VSS RBL RBLB WL47 Replica_CELL
XReplica_CELL_48 VDD VSS RBL RBLB WL48 Replica_CELL
XReplica_CELL_49 VDD VSS RBL RBLB WL49 Replica_CELL
XReplica_CELL_50 VDD VSS RBL RBLB WL50 Replica_CELL
XReplica_CELL_51 VDD VSS RBL RBLB WL51 Replica_CELL
XReplica_CELL_52 VDD VSS RBL RBLB WL52 Replica_CELL
XReplica_CELL_53 VDD VSS RBL RBLB WL53 Replica_CELL
XReplica_CELL_54 VDD VSS RBL RBLB WL54 Replica_CELL
XReplica_CELL_55 VDD VSS RBL RBLB WL55 Replica_CELL
XReplica_CELL_56 VDD VSS RBL RBLB WL56 Replica_CELL
XReplica_CELL_57 VDD VSS RBL RBLB WL57 Replica_CELL
XReplica_CELL_58 VDD VSS RBL RBLB WL58 Replica_CELL
XReplica_CELL_59 VDD VSS RBL RBLB WL59 Replica_CELL
XReplica_CELL_60 VDD VSS RBL RBLB WL60 Replica_CELL
XReplica_CELL_61 VDD VSS RBL RBLB WL61 Replica_CELL
XReplica_CELL_62 VDD VSS RBL RBLB WL62 Replica_CELL
XReplica_CELL_63 VDD VSS RBL RBLB WL63 Replica_CELL
XReplica_CELL_64 VDD VSS RBL RBLB WL64 Replica_CELL
.ends sram_65x1_replica_column

.subckt Replica_CELL VDD VSS RBL RBLB WL
MPGL RBL WL Q VSS NMOS_VTG l=5e-08 w=1.35e-07
MPGR RBLB WL VDD VSS NMOS_VTG l=5e-08 w=1.35e-07
MPDL Q VDD VSS VSS NMOS_VTG l=5e-08 w=2.05e-07
MPUL Q VDD VDD VDD PMOS_VTG l=5e-08 w=9e-08
MPDR VDD Q VSS VSS NMOS_VTG l=5e-08 w=2.05e-07
MPUR VDD Q VDD VDD PMOS_VTG l=5e-08 w=9e-08
.ends Replica_CELL

.subckt AND2 VDD VSS A B Z
XPNAND3 VDD VSS A B zb_int PNAND2
XPINV VDD VSS zb_int Z PINV
.ends AND2

.subckt PNAND2 VDD VSS A B Z
Mpnand2_pmos1 Z A VDD VDD PMOS_VTG l=5e-08 w=2.7e-07
Mpnand2_pmos2 Z B VDD VDD PMOS_VTG l=5e-08 w=2.7e-07
Mpnand2_nmos1 Z B net1 VSS NMOS_VTG l=5e-08 w=1.8e-07
Mpnand2_nmos2 net1 A VSS VSS NMOS_VTG l=5e-08 w=1.8e-07
.ends PNAND2

.subckt PINV VDD VSS A Z
Mpinv_pmos Z A VDD VDD PMOS_VTG l=5e-08 w=2.7e-07
Mpinv_nmos Z A VSS VSS NMOS_VTG l=5e-08 w=9e-08
.ends PINV

.subckt TIME VDD VSS clk csb web clk_buf clk_bar cs_bar cs we_bar we gated_clk_bar gated_clk_buf wl_en A0 A1 A2 A3 A4 A5 A_dff0 A_dff1 A_dff2 A_dff3 A_dff4 A_dff5 DIN0 DIN1 DIN2 DIN3 DIN4 DIN5 DIN6 DIN7 DIN_dff0 DIN_dff1 DIN_dff2 DIN_dff3 DIN_dff4 DIN_dff5 DIN_dff6 DIN_dff7 rbl rbl_delay rbl_delay_bar s_en w_en PRE
Xdff_buf_addr VDD VSS clk_buf A0 A1 A2 A3 A4 A5 A_dff0 A_dff1 A_dff2 A_dff3 A_dff4 A_dff5 ADDR_DFF
Xdff_buf_data VDD VSS clk_buf DIN0 DIN1 DIN2 DIN3 DIN4 DIN5 DIN6 DIN7 DIN_dff0 DIN_dff1 DIN_dff2 DIN_dff3 DIN_dff4 DIN_dff5 DIN_dff6 DIN_dff7 DATA_DFF
Xclkbuf VDD VSS clk clk_buf pdrive
Xinv_clk_bar VDD VSS clk_buf clk_bar PINV
Xdff_buf VDD VSS csb cs_bar cs clk_buf DFF_BUF
Xdff_buf1 VDD VSS web we_bar we clk_buf DFF_BUF
Xand2_gated_clk_bar VDD VSS cs clk_bar gated_clk_bar AND2
Xand2_gated_clk_buf VDD VSS cs clk_buf gated_clk_buf AND2
Xwl_en VDD VSS gated_clk_bar wl_en wl_pdrive
Xinv_wl_en_bar VDD VSS wl_en wl_en_bar PINV_wl_en_bar
Xdelaychain VDD VSS rbl rbl_delay delay_chain
Xinv_rbl_delay_bar VDD VSS rbl_delay rbl_delay_bar PINV
Xw_en VDD VSS rbl_delay_bar gated_clk_bar we w_en AND3
Xs_en VDD VSS rbl_delay gated_clk_bar we_bar s_en AND3
Xpre_unbuf VDD VSS gated_clk_buf rbl_delay wl_en_bar PRE_UNBUF PNAND3
Xpre VDD VSS PRE_UNBUF PRE pdrive2_for_pre
.ends TIME

.subckt ADDR_DFF VDD VSS CLK A0 A1 A2 A3 A4 A5 A_dff0 A_dff1 A_dff2 A_dff3 A_dff4 A_dff5
Xdff_0 VDD VSS A0 A_dff0 CLK DFF
Xdff_1 VDD VSS A1 A_dff1 CLK DFF
Xdff_2 VDD VSS A2 A_dff2 CLK DFF
Xdff_3 VDD VSS A3 A_dff3 CLK DFF
Xdff_4 VDD VSS A4 A_dff4 CLK DFF
Xdff_5 VDD VSS A5 A_dff5 CLK DFF
.ends ADDR_DFF

.subckt DFF VDD VSS D Q CLK
Xinv1_clk VDD VSS CLK CLKB PINV1
Xinv2_D VDD VSS D D_b PINV1
Xtg1 VDD VSS D_b z1 CLK CLKB TRANSMISSION_GATE
Xinv3 VDD VSS z1 z2 PINV1
Xinv4 VDD VSS z2 z3 PINV1
Xtg2 VDD VSS z3 z1 CLKB CLK TRANSMISSION_GATE
Xinv5 VDD VSS z2 z4 PINV1
Xtg3 VDD VSS z4 z5 CLKB CLK TRANSMISSION_GATE
Xinv6 VDD VSS z5 Q PINV1
Xinv7 VDD VSS Q QB PINV1
Xtg4 VDD VSS QB z5 CLK CLKB TRANSMISSION_GATE
.ends DFF

.subckt PINV1 VDD VSS A Z
Mpinv_pmos Z A VDD VDD PMOS_VTG l=5e-08 w=5e-07
Mpinv_nmos Z A VSS VSS NMOS_VTG l=5e-08 w=2.5e-07
.ends PINV1

.subckt TRANSMISSION_GATE VDD VSS IN OUT CTR_P CTR_N
Mtranspmos OUT CTR_P IN VDD PMOS_VTG l=5e-08 w=5e-07
Mtransnmos IN CTR_N OUT VSS NMOS_VTG l=5e-08 w=2.5e-07
.ends TRANSMISSION_GATE

.subckt DATA_DFF VDD VSS CLK DIN0 DIN1 DIN2 DIN3 DIN4 DIN5 DIN6 DIN7 DIN_dff0 DIN_dff1 DIN_dff2 DIN_dff3 DIN_dff4 DIN_dff5 DIN_dff6 DIN_dff7
Xdff_0 VDD VSS DIN0 DIN_dff0 CLK DFF
Xdff_1 VDD VSS DIN1 DIN_dff1 CLK DFF
Xdff_2 VDD VSS DIN2 DIN_dff2 CLK DFF
Xdff_3 VDD VSS DIN3 DIN_dff3 CLK DFF
Xdff_4 VDD VSS DIN4 DIN_dff4 CLK DFF
Xdff_5 VDD VSS DIN5 DIN_dff5 CLK DFF
Xdff_6 VDD VSS DIN6 DIN_dff6 CLK DFF
Xdff_7 VDD VSS DIN7 DIN_dff7 CLK DFF
.ends DATA_DFF

.subckt DFF VDD VSS D Q CLK
Xinv1_clk VDD VSS CLK CLKB PINV1
Xinv2_D VDD VSS D D_b PINV1
Xtg1 VDD VSS D_b z1 CLK CLKB TRANSMISSION_GATE
Xinv3 VDD VSS z1 z2 PINV1
Xinv4 VDD VSS z2 z3 PINV1
Xtg2 VDD VSS z3 z1 CLKB CLK TRANSMISSION_GATE
Xinv5 VDD VSS z2 z4 PINV1
Xtg3 VDD VSS z4 z5 CLKB CLK TRANSMISSION_GATE
Xinv6 VDD VSS z5 Q PINV1
Xinv7 VDD VSS Q QB PINV1
Xtg4 VDD VSS QB z5 CLK CLKB TRANSMISSION_GATE
.ends DFF

.subckt PINV1 VDD VSS A Z
Mpinv_pmos Z A VDD VDD PMOS_VTG l=5e-08 w=5e-07
Mpinv_nmos Z A VSS VSS NMOS_VTG l=5e-08 w=2.5e-07
.ends PINV1

.subckt TRANSMISSION_GATE VDD VSS IN OUT CTR_P CTR_N
Mtranspmos OUT CTR_P IN VDD PMOS_VTG l=5e-08 w=5e-07
Mtransnmos IN CTR_N OUT VSS NMOS_VTG l=5e-08 w=2.5e-07
.ends TRANSMISSION_GATE

.subckt pdrive VDD VSS A Z
Xbuf_inv1 VDD VSS A zb1_node PINV1
Xbuf_inv2 VDD VSS zb1_node zb2_node PINV2
Xbuf_inv3 VDD VSS zb2_node zb3_node PINV3
Xbuf_inv4 VDD VSS zb3_node Z PINV4
.ends pdrive

.subckt PINV1 VDD VSS A Z
Mpinv_pmos Z A VDD VDD PMOS_VTG l=5e-08 w=2.7e-07
Mpinv_nmos Z A VSS VSS NMOS_VTG l=5e-08 w=9e-08
.ends PINV1

.subckt PINV2 VDD VSS A Z
Mpinv_pmos Z A VDD VDD PMOS_VTG l=5e-08 w=8.1e-07
Mpinv_nmos Z A VSS VSS NMOS_VTG l=5e-08 w=2.7e-07
.ends PINV2

.subckt PINV3 VDD VSS A Z
Mpinv_pmos Z A VDD VDD PMOS_VTG l=5e-08 w=2.43e-06
Mpinv_nmos Z A VSS VSS NMOS_VTG l=5e-08 w=9.1e-07
.ends PINV3

.subckt PINV4 VDD VSS A Z
Mpinv_pmos Z A VDD VDD PMOS_VTG l=5e-08 w=7.29e-06
Mpinv_nmos Z A VSS VSS NMOS_VTG l=5e-08 w=2.43e-06
.ends PINV4

.subckt PINV VDD VSS A Z
Mpinv_pmos Z A VDD VDD PMOS_VTG l=5e-08 w=2.7e-07
Mpinv_nmos Z A VSS VSS NMOS_VTG l=5e-08 w=9e-08
.ends PINV

.subckt DFF_BUF VDD VSS D Q QB CLK
Xdff VDD VSS D qint CLK DFF
Xinv1 VDD VSS qint QB PINV1
Xinv2 VDD VSS QB Q PINV2
.ends DFF_BUF

.subckt DFF VDD VSS D Q CLK
Xinv1_clk VDD VSS CLK CLKB PINV1
Xinv2_D VDD VSS D D_b PINV1
Xtg1 VDD VSS D_b z1 CLK CLKB TRANSMISSION_GATE
Xinv3 VDD VSS z1 z2 PINV1
Xinv4 VDD VSS z2 z3 PINV1
Xtg2 VDD VSS z3 z1 CLKB CLK TRANSMISSION_GATE
Xinv5 VDD VSS z2 z4 PINV1
Xtg3 VDD VSS z4 z5 CLKB CLK TRANSMISSION_GATE
Xinv6 VDD VSS z5 Q PINV1
Xinv7 VDD VSS Q QB PINV1
Xtg4 VDD VSS QB z5 CLK CLKB TRANSMISSION_GATE
.ends DFF

.subckt PINV1 VDD VSS A Z
Mpinv_pmos Z A VDD VDD PMOS_VTG l=5e-08 w=5e-07
Mpinv_nmos Z A VSS VSS NMOS_VTG l=5e-08 w=2.5e-07
.ends PINV1

.subckt TRANSMISSION_GATE VDD VSS IN OUT CTR_P CTR_N
Mtranspmos OUT CTR_P IN VDD PMOS_VTG l=5e-08 w=5e-07
Mtransnmos IN CTR_N OUT VSS NMOS_VTG l=5e-08 w=2.5e-07
.ends TRANSMISSION_GATE

.subckt PINV1 VDD VSS A Z
Mpinv_pmos Z A VDD VDD PMOS_VTG l=5e-08 w=5.4e-07
Mpinv_nmos Z A VSS VSS NMOS_VTG l=5e-08 w=1.8e-07
.ends PINV1

.subckt PINV2 VDD VSS A Z
Mpinv_pmos Z A VDD VDD PMOS_VTG l=5e-08 w=1.08e-06
Mpinv_nmos Z A VSS VSS NMOS_VTG l=5e-08 w=3.6e-07
.ends PINV2

.subckt AND2 VDD VSS A B Z
XPNAND3 VDD VSS A B zb_int PNAND2
XPINV VDD VSS zb_int Z PINV
.ends AND2

.subckt PNAND2 VDD VSS A B Z
Mpnand2_pmos1 Z A VDD VDD PMOS_VTG l=5e-08 w=2.7e-07
Mpnand2_pmos2 Z B VDD VDD PMOS_VTG l=5e-08 w=2.7e-07
Mpnand2_nmos1 Z B net1 VSS NMOS_VTG l=5e-08 w=1.8e-07
Mpnand2_nmos2 net1 A VSS VSS NMOS_VTG l=5e-08 w=1.8e-07
.ends PNAND2

.subckt PINV VDD VSS A Z
Mpinv_pmos Z A VDD VDD PMOS_VTG l=5e-08 w=1.62e-06
Mpinv_nmos Z A VSS VSS NMOS_VTG l=5e-08 w=5.4e-07
.ends PINV

.subckt wl_pdrive VDD VSS A Z
Xbuf_inv1 VDD VSS A zb1_node PINV1
Xbuf_inv2 VDD VSS zb1_node Z PINV2
.ends wl_pdrive

.subckt PINV1 VDD VSS A Z
Mpinv_pmos Z A VDD VDD PMOS_VTG l=5e-08 w=2.7e-07
Mpinv_nmos Z A VSS VSS NMOS_VTG l=5e-08 w=9e-08
.ends PINV1

.subckt PINV2 VDD VSS A Z
Mpinv_pmos Z A VDD VDD PMOS_VTG l=5e-08 w=1.35e-06
Mpinv_nmos Z A VSS VSS NMOS_VTG l=5e-08 w=4.5e-07
.ends PINV2

.subckt PINV_wl_en_bar VDD VSS A Z
Mpinv_pmos Z A VDD VDD PMOS_VTG l=5e-08 w=2.7e-07
Mpinv_nmos Z A VSS VSS NMOS_VTG l=5e-08 w=9e-08
.ends PINV_wl_en_bar

.subckt delay_chain VDD VSS in out
Xdinv0 VDD VSS in dout_1 PINV1
Xdload_0_0 VDD VSS dout_1 n_0_0 PINV1
Xdload_0_1 VDD VSS dout_1 n_0_1 PINV1
Xdload_0_2 VDD VSS dout_1 n_0_2 PINV1
Xdload_0_3 VDD VSS dout_1 n_0_3 PINV1
Xdinv1 VDD VSS dout_1 dout_2 PINV1
Xdload_1_0 VDD VSS dout_2 n_1_0 PINV1
Xdload_1_1 VDD VSS dout_2 n_1_1 PINV1
Xdload_1_2 VDD VSS dout_2 n_1_2 PINV1
Xdload_1_3 VDD VSS dout_2 n_1_3 PINV1
Xdinv2 VDD VSS dout_2 dout_3 PINV1
Xdload_2_0 VDD VSS dout_3 n_2_0 PINV1
Xdload_2_1 VDD VSS dout_3 n_2_1 PINV1
Xdload_2_2 VDD VSS dout_3 n_2_2 PINV1
Xdload_2_3 VDD VSS dout_3 n_2_3 PINV1
Xdinv3 VDD VSS dout_3 dout_4 PINV1
Xdload_3_0 VDD VSS dout_4 n_3_0 PINV1
Xdload_3_1 VDD VSS dout_4 n_3_1 PINV1
Xdload_3_2 VDD VSS dout_4 n_3_2 PINV1
Xdload_3_3 VDD VSS dout_4 n_3_3 PINV1
Xdinv4 VDD VSS dout_4 dout_5 PINV1
Xdload_4_0 VDD VSS dout_5 n_4_0 PINV1
Xdload_4_1 VDD VSS dout_5 n_4_1 PINV1
Xdload_4_2 VDD VSS dout_5 n_4_2 PINV1
Xdload_4_3 VDD VSS dout_5 n_4_3 PINV1
Xdinv5 VDD VSS dout_5 dout_6 PINV1
Xdload_5_0 VDD VSS dout_6 n_5_0 PINV1
Xdload_5_1 VDD VSS dout_6 n_5_1 PINV1
Xdload_5_2 VDD VSS dout_6 n_5_2 PINV1
Xdload_5_3 VDD VSS dout_6 n_5_3 PINV1
Xdinv6 VDD VSS dout_6 dout_7 PINV1
Xdload_6_0 VDD VSS dout_7 n_6_0 PINV1
Xdload_6_1 VDD VSS dout_7 n_6_1 PINV1
Xdload_6_2 VDD VSS dout_7 n_6_2 PINV1
Xdload_6_3 VDD VSS dout_7 n_6_3 PINV1
Xdinv7 VDD VSS dout_7 dout_8 PINV1
Xdload_7_0 VDD VSS dout_8 n_7_0 PINV1
Xdload_7_1 VDD VSS dout_8 n_7_1 PINV1
Xdload_7_2 VDD VSS dout_8 n_7_2 PINV1
Xdload_7_3 VDD VSS dout_8 n_7_3 PINV1
Xdinv8 VDD VSS dout_8 out PINV1
Xdload_8_0 VDD VSS out n_8_0 PINV1
Xdload_8_1 VDD VSS out n_8_1 PINV1
Xdload_8_2 VDD VSS out n_8_2 PINV1
Xdload_8_3 VDD VSS out n_8_3 PINV1
.ends delay_chain

.subckt PINV1 VDD VSS A Z
Mpinv_pmos Z A VDD VDD PMOS_VTG l=5e-08 w=2.7e-07
Mpinv_nmos Z A VSS VSS NMOS_VTG l=5e-08 w=9e-08
.ends PINV1

.subckt AND3 VDD VSS A B C Z
XPNAND3 VDD VSS A B C zb_int PNAND3
XPINV VDD VSS zb_int Z PINV
.ends AND3

.subckt PNAND3 VDD VSS A B C Z
Mpnand3_pmos1 Z A VDD VDD PMOS_VTG l=5e-08 w=2.7e-07
Mpnand3_pmos2 Z B VDD VDD PMOS_VTG l=5e-08 w=2.7e-07
Mpnand3_pmos3 Z C VDD VDD PMOS_VTG l=5e-08 w=2.7e-07
Mpnand3_nmos1 Z A net1 VSS NMOS_VTG l=5e-08 w=1.8e-07
Mpnand3_nmos2 net1 B net2 VSS NMOS_VTG l=5e-08 w=1.8e-07
Mpnand3_nmos3 net2 C VSS VSS NMOS_VTG l=5e-08 w=1.8e-07
.ends PNAND3

.subckt PINV VDD VSS A Z
Mpinv_pmos Z A VDD VDD PMOS_VTG l=5e-08 w=1.08e-06
Mpinv_nmos Z A VSS VSS NMOS_VTG l=5e-08 w=3.6e-07
.ends PINV

.subckt PNAND3 VDD VSS A B C Z
Mpnand3_pmos1 Z A VDD VDD PMOS_VTG l=5e-08 w=2.7e-07
Mpnand3_pmos2 Z B VDD VDD PMOS_VTG l=5e-08 w=2.7e-07
Mpnand3_pmos3 Z C VDD VDD PMOS_VTG l=5e-08 w=2.7e-07
Mpnand3_nmos1 Z A net1 VSS NMOS_VTG l=5e-08 w=2.7e-07
Mpnand3_nmos2 net1 B net2 VSS NMOS_VTG l=5e-08 w=2.7e-07
Mpnand3_nmos3 net2 C VSS VSS NMOS_VTG l=5e-08 w=2.7e-07
.ends PNAND3

.subckt pdrive2_for_pre VDD VSS A Z
Xbuf_inv1 VDD VSS A zb1_node PINV1
Xbuf_inv2 VDD VSS zb1_node Z PINV2
.ends pdrive2_for_pre

.subckt PINV1 VDD VSS A Z
Mpinv_pmos Z A VDD VDD PMOS_VTG l=5e-08 w=2.7e-07
Mpinv_nmos Z A VSS VSS NMOS_VTG l=5e-08 w=9e-08
.ends PINV1

.subckt PINV2 VDD VSS A Z
Mpinv_pmos Z A VDD VDD PMOS_VTG l=5e-08 w=8.1e-07
Mpinv_nmos Z A VSS VSS NMOS_VTG l=5e-08 w=2.7e-07
.ends PINV2

.subckt DECODER_CASCADE VDD VSS A0 A1 A2 A3 A4 A5 WL0 WL1 WL2 WL3 WL4 WL5 WL6 WL7 WL8 WL9 WL10 WL11 WL12 WL13 WL14 WL15 WL16 WL17 WL18 WL19 WL20 WL21 WL22 WL23 WL24 WL25 WL26 WL27 WL28 WL29 WL30 WL31 WL32 WL33 WL34 WL35 WL36 WL37 WL38 WL39 WL40 WL41 WL42 WL43 WL44 WL45 WL46 WL47 WL48 WL49 WL50 WL51 WL52 WL53 WL54 WL55 WL56 WL57 WL58 WL59 WL60 WL61 WL62 WL63
XDEC_0_0 VDD VSS VDD A5 A4 A3 EN_0_0_0 EN_0_0_1 EN_0_0_2 EN_0_0_3 EN_0_0_4 EN_0_0_5 EN_0_0_6 EN_0_0_7 DECODER3_8
XDEC_1_0 VDD VSS EN_0_0_0 A2 A1 A0 WL0 WL1 WL2 WL3 WL4 WL5 WL6 WL7 DECODER3_8
XDEC_1_1 VDD VSS EN_0_0_1 A2 A1 A0 WL8 WL9 WL10 WL11 WL12 WL13 WL14 WL15 DECODER3_8
XDEC_1_2 VDD VSS EN_0_0_2 A2 A1 A0 WL16 WL17 WL18 WL19 WL20 WL21 WL22 WL23 DECODER3_8
XDEC_1_3 VDD VSS EN_0_0_3 A2 A1 A0 WL24 WL25 WL26 WL27 WL28 WL29 WL30 WL31 DECODER3_8
XDEC_1_4 VDD VSS EN_0_0_4 A2 A1 A0 WL32 WL33 WL34 WL35 WL36 WL37 WL38 WL39 DECODER3_8
XDEC_1_5 VDD VSS EN_0_0_5 A2 A1 A0 WL40 WL41 WL42 WL43 WL44 WL45 WL46 WL47 DECODER3_8
XDEC_1_6 VDD VSS EN_0_0_6 A2 A1 A0 WL48 WL49 WL50 WL51 WL52 WL53 WL54 WL55 DECODER3_8
XDEC_1_7 VDD VSS EN_0_0_7 A2 A1 A0 WL56 WL57 WL58 WL59 WL60 WL61 WL62 WL63 DECODER3_8
.ends DECODER_CASCADE

.subckt DECODER3_8 VDD VSS EN A0 A1 A2 WL0 WL1 WL2 WL3 WL4 WL5 WL6 WL7
XINV_A1 VDD VSS A0 A0b PINV
XINV_A2 VDD VSS A1 A1b PINV
XINV_A3 VDD VSS A2 A2b PINV
XAND0 VDD VSS A0b A1b A2b WL0_pre AND3
XAND_EN0 VDD VSS WL0_pre EN WL0 AND2
XAND1 VDD VSS A0b A1b A2 WL1_pre AND3
XAND_EN1 VDD VSS WL1_pre EN WL1 AND2
XAND2 VDD VSS A0b A1 A2b WL2_pre AND3
XAND_EN2 VDD VSS WL2_pre EN WL2 AND2
XAND3 VDD VSS A0b A1 A2 WL3_pre AND3
XAND_EN3 VDD VSS WL3_pre EN WL3 AND2
XAND4 VDD VSS A0 A1b A2b WL4_pre AND3
XAND_EN4 VDD VSS WL4_pre EN WL4 AND2
XAND5 VDD VSS A0 A1b A2 WL5_pre AND3
XAND_EN5 VDD VSS WL5_pre EN WL5 AND2
XAND6 VDD VSS A0 A1 A2b WL6_pre AND3
XAND_EN6 VDD VSS WL6_pre EN WL6 AND2
XAND7 VDD VSS A0 A1 A2 WL7_pre AND3
XAND_EN7 VDD VSS WL7_pre EN WL7 AND2
.ends DECODER3_8

.subckt PINV VDD VSS A Z
Mpinv_pmos Z A VDD VDD PMOS_VTG l=5e-08 w=2.7e-07
Mpinv_nmos Z A VSS VSS NMOS_VTG l=5e-08 w=9e-08
.ends PINV

.subckt AND3 VDD VSS A B C Z
XPNAND3 VDD VSS A B C zb_int PNAND3
XPINV VDD VSS zb_int Z PINV
.ends AND3

.subckt PNAND3 VDD VSS A B C Z
Mpnand3_pmos1 Z A VDD VDD PMOS_VTG l=5e-08 w=2.7e-07
Mpnand3_pmos2 Z B VDD VDD PMOS_VTG l=5e-08 w=2.7e-07
Mpnand3_pmos3 Z C VDD VDD PMOS_VTG l=5e-08 w=2.7e-07
Mpnand3_nmos1 Z A net1 VSS NMOS_VTG l=5e-08 w=1.8e-07
Mpnand3_nmos2 net1 B net2 VSS NMOS_VTG l=5e-08 w=1.8e-07
Mpnand3_nmos3 net2 C VSS VSS NMOS_VTG l=5e-08 w=1.8e-07
.ends PNAND3

.subckt PINV VDD VSS A Z
Mpinv_pmos Z A VDD VDD PMOS_VTG l=5e-08 w=2.7e-07
Mpinv_nmos Z A VSS VSS NMOS_VTG l=5e-08 w=9e-08
.ends PINV

.subckt AND2 VDD VSS A B Z
XPNAND3 VDD VSS A B zb_int PNAND2
XPINV VDD VSS zb_int Z PINV
.ends AND2

.subckt PNAND2 VDD VSS A B Z
Mpnand2_pmos1 Z A VDD VDD PMOS_VTG l=5e-08 w=2.7e-07
Mpnand2_pmos2 Z B VDD VDD PMOS_VTG l=5e-08 w=2.7e-07
Mpnand2_nmos1 Z B net1 VSS NMOS_VTG l=5e-08 w=1.8e-07
Mpnand2_nmos2 net1 A VSS VSS NMOS_VTG l=5e-08 w=1.8e-07
.ends PNAND2

.subckt PINV VDD VSS A Z
Mpinv_pmos Z A VDD VDD PMOS_VTG l=5e-08 w=2.7e-07
Mpinv_nmos Z A VSS VSS NMOS_VTG l=5e-08 w=9e-08
.ends PINV

.subckt WORDLINEDRIVER VDD VSS A B Z
XPNAND2 VDD VSS A B zb_int PNAND2
XPINV VDD VSS zb_int Z PINV
.ends WORDLINEDRIVER

.subckt PNAND2 VDD VSS A B Z
Mpnand2_pmos1 Z A VDD VDD PMOS_VTG l=5e-08 w=2.7e-07
Mpnand2_pmos2 Z B VDD VDD PMOS_VTG l=5e-08 w=2.7e-07
Mpnand2_nmos1 Z B net1 VSS NMOS_VTG l=5e-08 w=1.8e-07
Mpnand2_nmos2 net1 A VSS VSS NMOS_VTG l=5e-08 w=1.8e-07
.ends PNAND2

.subckt PINV VDD VSS A Z
Mpinv_pmos Z A VDD VDD PMOS_VTG l=5e-08 w=5.4e-07
Mpinv_nmos Z A VSS VSS NMOS_VTG l=5e-08 w=1.8e-07
.ends PINV

.subckt D_LATCH VDD VSS D EN Q QB
XINV1 VDD VSS D DB PINV
XNAND1 VDD VSS D EN INT1 PNAND2
XNAND2 VDD VSS DB EN INT2 PNAND2
XNAND3 VDD VSS INT1 QB Q PNAND2
XNAND4 VDD VSS INT2 Q QB PNAND2
.ends D_LATCH

.subckt PNAND2 VDD VSS A B Z
Mpnand2_pmos1 Z A VDD VDD PMOS_VTG l=5e-08 w=2.7e-07
Mpnand2_pmos2 Z B VDD VDD PMOS_VTG l=5e-08 w=2.7e-07
Mpnand2_nmos1 Z B net1 VSS NMOS_VTG l=5e-08 w=1.8e-07
Mpnand2_nmos2 net1 A VSS VSS NMOS_VTG l=5e-08 w=1.8e-07
.ends PNAND2

.subckt PINV VDD VSS A Z
Mpinv_pmos Z A VDD VDD PMOS_VTG l=5e-08 w=2.7e-07
Mpinv_nmos Z A VSS VSS NMOS_VTG l=5e-08 w=1.8e-07
.ends PINV

.subckt PRECHARGE VDD ENB BL BLB
M1 BL ENB VDD VDD PMOS_VTG l=5e-08 w=1.08e-06
M2 BLB ENB VDD VDD PMOS_VTG l=5e-08 w=1.08e-06
M3 BL ENB BLB VDD PMOS_VTG l=5e-08 w=1.08e-06
.ends PRECHARGE

.subckt SENSEAMP VDD VSS EN IN INB Q QB
M1 Q QB net1 VSS NMOS_VTG l=5e-08 w=2.7e-07
M2 Q QB VDD VDD PMOS_VTG l=5e-08 w=5.4e-07
M3 QB Q net1 VSS NMOS_VTG l=5e-08 w=2.7e-07
M4 QB Q VDD VDD PMOS_VTG l=5e-08 w=5.4e-07
M5 Q EN IN VDD PMOS_VTG l=5e-08 w=7.2e-07
M6 QB EN INB VDD PMOS_VTG l=5e-08 w=7.2e-07
M7 net1 EN VSS VSS NMOS_VTG l=5e-08 w=2.7e-07
.ends SENSEAMP

.subckt WRITEDRIVER VDD VSS EN DIN BL BLB
M1 DINB DIN VDD VDD PMOS_VTG l=5e-08 w=1.44e-06
M2 DINB DIN VSS VSS NMOS_VTG l=5e-08 w=7.2e-07
M3 ENB EN VDD VDD PMOS_VTG l=5e-08 w=1.44e-06
M4 ENB EN VSS VSS NMOS_VTG l=5e-08 w=7.2e-07
M5 int1 DINB VDD VDD PMOS_VTG l=5e-08 w=1.44e-06
M6 BL ENB int1 VDD PMOS_VTG l=5e-08 w=1.44e-06
M7 BL EN int2 VSS NMOS_VTG l=5e-08 w=7.2e-07
M8 int2 DINB VSS VSS NMOS_VTG l=5e-08 w=7.2e-07
M9 int3 DIN VDD VDD PMOS_VTG l=5e-08 w=1.44e-06
M10 BLB ENB int3 VDD PMOS_VTG l=5e-08 w=1.44e-06
M11 BLB EN int4 VSS NMOS_VTG l=5e-08 w=7.2e-07
M12 int4 DIN VSS VSS NMOS_VTG l=5e-08 w=7.2e-07
.ends WRITEDRIVER

.subckt OPENYIELD_SRAM_TOP_V1 VDD VSS clk csb web A0 A1 A2 A3 A4 A5 DIN0 DIN1 DIN2 DIN3 DIN4 DIN5 DIN6 DIN7 SA_Q0 SA_Q1 SA_Q2 SA_Q3 SA_Q4 SA_Q5 SA_Q6 SA_Q7 SA_QB0 SA_QB1 SA_QB2 SA_QB3 SA_QB4 SA_QB5 SA_QB6 SA_QB7
XSRAM_6T_CORE_64x8 VDD VSS BL0 BL1 BL2 BL3 BL4 BL5 BL6 BL7 BLB0 BLB1 BLB2 BLB3 BLB4 BLB5 BLB6 BLB7 WL0 WL1 WL2 WL3 WL4 WL5 WL6 WL7 WL8 WL9 WL10 WL11 WL12 WL13 WL14 WL15 WL16 WL17 WL18 WL19 WL20 WL21 WL22 WL23 WL24 WL25 WL26 WL27 WL28 WL29 WL30 WL31 WL32 WL33 WL34 WL35 WL36 WL37 WL38 WL39 WL40 WL41 WL42 WL43 WL44 WL45 WL46 WL47 WL48 WL49 WL50 WL51 WL52 WL53 WL54 WL55 WL56 WL57 WL58 WL59 WL60 WL61 WL62 WL63 SRAM_6T_CORE_64x8
Xsram_17x1_replica_column VDD VSS RBL RBLB RWL WL0 WL1 WL2 WL3 WL4 WL5 WL6 WL7 WL8 WL9 WL10 WL11 WL12 WL13 WL14 WL15 WL16 WL17 WL18 WL19 WL20 WL21 WL22 WL23 WL24 WL25 WL26 WL27 WL28 WL29 WL30 WL31 WL32 WL33 WL34 WL35 WL36 WL37 WL38 WL39 WL40 WL41 WL42 WL43 WL44 WL45 WL46 WL47 WL48 WL49 WL50 WL51 WL52 WL53 WL54 WL55 WL56 WL57 WL58 WL59 WL60 WL61 WL62 WL63 sram_65x1_replica_column
XRWL VDD VSS wl_en VDD RWL AND2
XTIME VDD VSS clk csb web clk_buf clk_bar cs_bar cs we_bar we gated_clk_bar gated_clk_buf wl_en A0 A1 A2 A3 A4 A5 A_dff0 A_dff1 A_dff2 A_dff3 A_dff4 A_dff5 DIN0 DIN1 DIN2 DIN3 DIN4 DIN5 DIN6 DIN7 DIN_dff0 DIN_dff1 DIN_dff2 DIN_dff3 DIN_dff4 DIN_dff5 DIN_dff6 DIN_dff7 rbl rbl_delay rbl_delay_bar s_en w_en PRE TIME
XDECODER VDD VSS A_dff0 A_dff1 A_dff2 A_dff3 A_dff4 A_dff5 DEC_WL0 DEC_WL1 DEC_WL2 DEC_WL3 DEC_WL4 DEC_WL5 DEC_WL6 DEC_WL7 DEC_WL8 DEC_WL9 DEC_WL10 DEC_WL11 DEC_WL12 DEC_WL13 DEC_WL14 DEC_WL15 DEC_WL16 DEC_WL17 DEC_WL18 DEC_WL19 DEC_WL20 DEC_WL21 DEC_WL22 DEC_WL23 DEC_WL24 DEC_WL25 DEC_WL26 DEC_WL27 DEC_WL28 DEC_WL29 DEC_WL30 DEC_WL31 DEC_WL32 DEC_WL33 DEC_WL34 DEC_WL35 DEC_WL36 DEC_WL37 DEC_WL38 DEC_WL39 DEC_WL40 DEC_WL41 DEC_WL42 DEC_WL43 DEC_WL44 DEC_WL45 DEC_WL46 DEC_WL47 DEC_WL48 DEC_WL49 DEC_WL50 DEC_WL51 DEC_WL52 DEC_WL53 DEC_WL54 DEC_WL55 DEC_WL56 DEC_WL57 DEC_WL58 DEC_WL59 DEC_WL60 DEC_WL61 DEC_WL62 DEC_WL63 DECODER_CASCADE
XWL_DRV_0 VDD VSS DEC_WL0 WL_EN WL0 WORDLINEDRIVER
XWL_DRV_1 VDD VSS DEC_WL1 WL_EN WL1 WORDLINEDRIVER
XWL_DRV_2 VDD VSS DEC_WL2 WL_EN WL2 WORDLINEDRIVER
XWL_DRV_3 VDD VSS DEC_WL3 WL_EN WL3 WORDLINEDRIVER
XWL_DRV_4 VDD VSS DEC_WL4 WL_EN WL4 WORDLINEDRIVER
XWL_DRV_5 VDD VSS DEC_WL5 WL_EN WL5 WORDLINEDRIVER
XWL_DRV_6 VDD VSS DEC_WL6 WL_EN WL6 WORDLINEDRIVER
XWL_DRV_7 VDD VSS DEC_WL7 WL_EN WL7 WORDLINEDRIVER
XWL_DRV_8 VDD VSS DEC_WL8 WL_EN WL8 WORDLINEDRIVER
XWL_DRV_9 VDD VSS DEC_WL9 WL_EN WL9 WORDLINEDRIVER
XWL_DRV_10 VDD VSS DEC_WL10 WL_EN WL10 WORDLINEDRIVER
XWL_DRV_11 VDD VSS DEC_WL11 WL_EN WL11 WORDLINEDRIVER
XWL_DRV_12 VDD VSS DEC_WL12 WL_EN WL12 WORDLINEDRIVER
XWL_DRV_13 VDD VSS DEC_WL13 WL_EN WL13 WORDLINEDRIVER
XWL_DRV_14 VDD VSS DEC_WL14 WL_EN WL14 WORDLINEDRIVER
XWL_DRV_15 VDD VSS DEC_WL15 WL_EN WL15 WORDLINEDRIVER
XWL_DRV_16 VDD VSS DEC_WL16 WL_EN WL16 WORDLINEDRIVER
XWL_DRV_17 VDD VSS DEC_WL17 WL_EN WL17 WORDLINEDRIVER
XWL_DRV_18 VDD VSS DEC_WL18 WL_EN WL18 WORDLINEDRIVER
XWL_DRV_19 VDD VSS DEC_WL19 WL_EN WL19 WORDLINEDRIVER
XWL_DRV_20 VDD VSS DEC_WL20 WL_EN WL20 WORDLINEDRIVER
XWL_DRV_21 VDD VSS DEC_WL21 WL_EN WL21 WORDLINEDRIVER
XWL_DRV_22 VDD VSS DEC_WL22 WL_EN WL22 WORDLINEDRIVER
XWL_DRV_23 VDD VSS DEC_WL23 WL_EN WL23 WORDLINEDRIVER
XWL_DRV_24 VDD VSS DEC_WL24 WL_EN WL24 WORDLINEDRIVER
XWL_DRV_25 VDD VSS DEC_WL25 WL_EN WL25 WORDLINEDRIVER
XWL_DRV_26 VDD VSS DEC_WL26 WL_EN WL26 WORDLINEDRIVER
XWL_DRV_27 VDD VSS DEC_WL27 WL_EN WL27 WORDLINEDRIVER
XWL_DRV_28 VDD VSS DEC_WL28 WL_EN WL28 WORDLINEDRIVER
XWL_DRV_29 VDD VSS DEC_WL29 WL_EN WL29 WORDLINEDRIVER
XWL_DRV_30 VDD VSS DEC_WL30 WL_EN WL30 WORDLINEDRIVER
XWL_DRV_31 VDD VSS DEC_WL31 WL_EN WL31 WORDLINEDRIVER
XWL_DRV_32 VDD VSS DEC_WL32 WL_EN WL32 WORDLINEDRIVER
XWL_DRV_33 VDD VSS DEC_WL33 WL_EN WL33 WORDLINEDRIVER
XWL_DRV_34 VDD VSS DEC_WL34 WL_EN WL34 WORDLINEDRIVER
XWL_DRV_35 VDD VSS DEC_WL35 WL_EN WL35 WORDLINEDRIVER
XWL_DRV_36 VDD VSS DEC_WL36 WL_EN WL36 WORDLINEDRIVER
XWL_DRV_37 VDD VSS DEC_WL37 WL_EN WL37 WORDLINEDRIVER
XWL_DRV_38 VDD VSS DEC_WL38 WL_EN WL38 WORDLINEDRIVER
XWL_DRV_39 VDD VSS DEC_WL39 WL_EN WL39 WORDLINEDRIVER
XWL_DRV_40 VDD VSS DEC_WL40 WL_EN WL40 WORDLINEDRIVER
XWL_DRV_41 VDD VSS DEC_WL41 WL_EN WL41 WORDLINEDRIVER
XWL_DRV_42 VDD VSS DEC_WL42 WL_EN WL42 WORDLINEDRIVER
XWL_DRV_43 VDD VSS DEC_WL43 WL_EN WL43 WORDLINEDRIVER
XWL_DRV_44 VDD VSS DEC_WL44 WL_EN WL44 WORDLINEDRIVER
XWL_DRV_45 VDD VSS DEC_WL45 WL_EN WL45 WORDLINEDRIVER
XWL_DRV_46 VDD VSS DEC_WL46 WL_EN WL46 WORDLINEDRIVER
XWL_DRV_47 VDD VSS DEC_WL47 WL_EN WL47 WORDLINEDRIVER
XWL_DRV_48 VDD VSS DEC_WL48 WL_EN WL48 WORDLINEDRIVER
XWL_DRV_49 VDD VSS DEC_WL49 WL_EN WL49 WORDLINEDRIVER
XWL_DRV_50 VDD VSS DEC_WL50 WL_EN WL50 WORDLINEDRIVER
XWL_DRV_51 VDD VSS DEC_WL51 WL_EN WL51 WORDLINEDRIVER
XWL_DRV_52 VDD VSS DEC_WL52 WL_EN WL52 WORDLINEDRIVER
XWL_DRV_53 VDD VSS DEC_WL53 WL_EN WL53 WORDLINEDRIVER
XWL_DRV_54 VDD VSS DEC_WL54 WL_EN WL54 WORDLINEDRIVER
XWL_DRV_55 VDD VSS DEC_WL55 WL_EN WL55 WORDLINEDRIVER
XWL_DRV_56 VDD VSS DEC_WL56 WL_EN WL56 WORDLINEDRIVER
XWL_DRV_57 VDD VSS DEC_WL57 WL_EN WL57 WORDLINEDRIVER
XWL_DRV_58 VDD VSS DEC_WL58 WL_EN WL58 WORDLINEDRIVER
XWL_DRV_59 VDD VSS DEC_WL59 WL_EN WL59 WORDLINEDRIVER
XWL_DRV_60 VDD VSS DEC_WL60 WL_EN WL60 WORDLINEDRIVER
XWL_DRV_61 VDD VSS DEC_WL61 WL_EN WL61 WORDLINEDRIVER
XWL_DRV_62 VDD VSS DEC_WL62 WL_EN WL62 WORDLINEDRIVER
XWL_DRV_63 VDD VSS DEC_WL63 WL_EN WL63 WORDLINEDRIVER
XPRECHARGE_0 VDD PRE BL0 BLB0 PRECHARGE
XPRECHARGE_1 VDD PRE BL1 BLB1 PRECHARGE
XPRECHARGE_2 VDD PRE BL2 BLB2 PRECHARGE
XPRECHARGE_3 VDD PRE BL3 BLB3 PRECHARGE
XPRECHARGE_4 VDD PRE BL4 BLB4 PRECHARGE
XPRECHARGE_5 VDD PRE BL5 BLB5 PRECHARGE
XPRECHARGE_6 VDD PRE BL6 BLB6 PRECHARGE
XPRECHARGE_7 VDD PRE BL7 BLB7 PRECHARGE
XPRECHARGE_RBL VDD PRE RBL RBLB PRECHARGE
XSENSEAMP_0 VDD VSS s_en BL0 BLB0 SA_Q0 SA_QB0 SENSEAMP
XSENSEAMP_1 VDD VSS s_en BL1 BLB1 SA_Q1 SA_QB1 SENSEAMP
XSENSEAMP_2 VDD VSS s_en BL2 BLB2 SA_Q2 SA_QB2 SENSEAMP
XSENSEAMP_3 VDD VSS s_en BL3 BLB3 SA_Q3 SA_QB3 SENSEAMP
XSENSEAMP_4 VDD VSS s_en BL4 BLB4 SA_Q4 SA_QB4 SENSEAMP
XSENSEAMP_5 VDD VSS s_en BL5 BLB5 SA_Q5 SA_QB5 SENSEAMP
XSENSEAMP_6 VDD VSS s_en BL6 BLB6 SA_Q6 SA_QB6 SENSEAMP
XSENSEAMP_7 VDD VSS s_en BL7 BLB7 SA_Q7 SA_QB7 SENSEAMP
XWRITEDRIVER_0 VDD VSS w_en DIN_dff0 BL0 BLB0 WRITEDRIVER
XWRITEDRIVER_1 VDD VSS w_en DIN_dff1 BL1 BLB1 WRITEDRIVER
XWRITEDRIVER_2 VDD VSS w_en DIN_dff2 BL2 BLB2 WRITEDRIVER
XWRITEDRIVER_3 VDD VSS w_en DIN_dff3 BL3 BLB3 WRITEDRIVER
XWRITEDRIVER_4 VDD VSS w_en DIN_dff4 BL4 BLB4 WRITEDRIVER
XWRITEDRIVER_5 VDD VSS w_en DIN_dff5 BL5 BLB5 WRITEDRIVER
XWRITEDRIVER_6 VDD VSS w_en DIN_dff6 BL6 BLB6 WRITEDRIVER
XWRITEDRIVER_7 VDD VSS w_en DIN_dff7 BL7 BLB7 WRITEDRIVER
.ends OPENYIELD_SRAM_TOP_V1
