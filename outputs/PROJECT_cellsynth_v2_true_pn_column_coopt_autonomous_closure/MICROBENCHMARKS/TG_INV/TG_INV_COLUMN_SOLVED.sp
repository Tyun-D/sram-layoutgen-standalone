.subckt TG_INV_COLUMN_SOLVED VDD VSS D CLK CLKB Y
M0 X CLKB D VDD PMOS_VTG W=0.5U L=0.05U
M1 X CLK D VSS NMOS_VTG W=0.25U L=0.05U
M2 Y X VDD VDD PMOS_VTG W=0.5U L=0.05U
M3 Y X VSS VSS NMOS_VTG W=0.25U L=0.05U
.ends TG_INV_COLUMN_SOLVED
.end
