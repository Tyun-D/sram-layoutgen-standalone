* cell TG_INV_COLUMN_SOLVED
* pin Y
* pin D
* pin CLK
* pin CLKB
* pin VDD
* pin VSS
.SUBCKT TG_INV_COLUMN_SOLVED 2 3 4 5 6 7
* net 2 Y
* net 3 D
* net 4 CLK
* net 5 CLKB
* net 6 VDD
* net 7 VSS
* device instance $1 r0 *1 3,7 PMOS_VTG
M$1 2 1 6 6 PMOS_VTG L=0.05U W=0.5U AS=0.2875P AD=0.2875P PS=2.15U PD=2.15U
* device instance $2 r0 *1 1.2,7 PMOS_VTG
M$2 1 5 3 6 PMOS_VTG L=0.05U W=0.5U AS=0.2875P AD=0.2875P PS=2.15U PD=2.15U
* device instance $3 r0 *1 3,2 NMOS_VTG
M$3 2 1 7 7 NMOS_VTG L=0.05U W=0.25U AS=0.14375P AD=0.14375P PS=1.65U PD=1.65U
* device instance $4 r0 *1 1.2,2 NMOS_VTG
M$4 1 4 3 7 NMOS_VTG L=0.05U W=0.25U AS=0.14375P AD=0.14375P PS=1.65U PD=1.65U
.ENDS TG_INV_COLUMN_SOLVED
