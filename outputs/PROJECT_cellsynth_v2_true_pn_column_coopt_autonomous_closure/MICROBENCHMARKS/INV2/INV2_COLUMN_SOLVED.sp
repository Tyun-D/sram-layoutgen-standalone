.subckt INV2_COLUMN_SOLVED VDD VSS A Y
M0 Y A VDD VDD PMOS_VTG W=0.5U L=0.05U
M1 Y A VSS VSS NMOS_VTG W=0.25U L=0.05U
.ends INV2_COLUMN_SOLVED
.end
