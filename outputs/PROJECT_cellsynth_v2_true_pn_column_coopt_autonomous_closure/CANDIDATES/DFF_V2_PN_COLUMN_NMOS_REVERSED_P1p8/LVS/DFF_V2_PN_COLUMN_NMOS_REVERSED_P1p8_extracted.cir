* cell DFF_V2_PN_COLUMN_NMOS_REVERSED_P1p8
* pin Q
* pin CLK,D
* pin VDD
* pin VSS
.SUBCKT DFF_V2_PN_COLUMN_NMOS_REVERSED_P1p8 4 6 8 9
* net 4 Q
* net 6 CLK,D
* net 8 VDD
* net 9 VSS
* device instance $1 r0 *1 19.2,7 PMOS_VTG
M$1 6 6 1 8 PMOS_VTG L=0.05U W=0.5U AS=0.2875P AD=0.2875P PS=2.15U PD=2.15U
* device instance $2 r0 *1 17.4,7 PMOS_VTG
M$2 6 5 2 8 PMOS_VTG L=0.05U W=0.5U AS=0.2875P AD=0.2875P PS=2.15U PD=2.15U
* device instance $3 r0 *1 15.6,7 PMOS_VTG
M$3 6 5 3 8 PMOS_VTG L=0.05U W=0.5U AS=0.2875P AD=0.2875P PS=2.15U PD=2.15U
* device instance $4 r0 *1 13.8,7 PMOS_VTG
M$4 6 6 7 8 PMOS_VTG L=0.05U W=0.5U AS=0.2875P AD=0.2875P PS=2.15U PD=2.15U
* device instance $5 r0 *1 12,7 PMOS_VTG
M$5 1 4 8 8 PMOS_VTG L=0.05U W=0.5U AS=0.2875P AD=0.2875P PS=2.15U PD=2.15U
* device instance $6 r0 *1 1.2,7 PMOS_VTG
M$6 5 6 8 8 PMOS_VTG L=0.05U W=0.5U AS=0.2875P AD=0.2875P PS=2.15U PD=2.15U
* device instance $7 r0 *1 10.2,7 PMOS_VTG
M$7 4 6 8 8 PMOS_VTG L=0.05U W=0.5U AS=0.2875P AD=0.2875P PS=2.15U PD=2.15U
* device instance $8 r0 *1 3,7 PMOS_VTG
M$8 7 6 8 8 PMOS_VTG L=0.05U W=0.5U AS=0.2875P AD=0.2875P PS=2.15U PD=2.15U
* device instance $9 r0 *1 4.8,7 PMOS_VTG
M$9 6 6 8 8 PMOS_VTG L=0.05U W=0.5U AS=0.2875P AD=0.2875P PS=2.15U PD=2.15U
* device instance $10 r0 *1 6.6,7 PMOS_VTG
M$10 3 6 8 8 PMOS_VTG L=0.05U W=0.5U AS=0.2875P AD=0.2875P PS=2.15U PD=2.15U
* device instance $11 r0 *1 8.4,7 PMOS_VTG
M$11 2 6 8 8 PMOS_VTG L=0.05U W=0.5U AS=0.2875P AD=0.2875P PS=2.15U PD=2.15U
* device instance $12 r0 *1 19.2,2 NMOS_VTG
M$12 5 6 9 9 NMOS_VTG L=0.05U W=0.25U AS=0.14375P AD=0.14375P PS=1.65U PD=1.65U
* device instance $13 r0 *1 15.6,2 NMOS_VTG
M$13 6 6 9 9 NMOS_VTG L=0.05U W=0.25U AS=0.14375P AD=0.14375P PS=1.65U PD=1.65U
* device instance $14 r0 *1 13.8,2 NMOS_VTG
M$14 3 6 9 9 NMOS_VTG L=0.05U W=0.25U AS=0.14375P AD=0.14375P PS=1.65U PD=1.65U
* device instance $15 r0 *1 12,2 NMOS_VTG
M$15 2 6 9 9 NMOS_VTG L=0.05U W=0.25U AS=0.14375P AD=0.14375P PS=1.65U PD=1.65U
* device instance $16 r0 *1 1.2,2 NMOS_VTG
M$16 1 5 6 9 NMOS_VTG L=0.05U W=0.25U AS=0.14375P AD=0.14375P PS=1.65U PD=1.65U
* device instance $17 r0 *1 17.4,2 NMOS_VTG
M$17 7 6 9 9 NMOS_VTG L=0.05U W=0.25U AS=0.14375P AD=0.14375P PS=1.65U PD=1.65U
* device instance $18 r0 *1 6.6,2 NMOS_VTG
M$18 7 5 6 9 NMOS_VTG L=0.05U W=0.25U AS=0.14375P AD=0.14375P PS=1.65U PD=1.65U
* device instance $19 r0 *1 3,2 NMOS_VTG
M$19 2 6 6 9 NMOS_VTG L=0.05U W=0.25U AS=0.14375P AD=0.14375P PS=1.65U PD=1.65U
* device instance $20 r0 *1 10.2,2 NMOS_VTG
M$20 4 6 9 9 NMOS_VTG L=0.05U W=0.25U AS=0.14375P AD=0.14375P PS=1.65U PD=1.65U
* device instance $21 r0 *1 4.8,2 NMOS_VTG
M$21 3 6 6 9 NMOS_VTG L=0.05U W=0.25U AS=0.14375P AD=0.14375P PS=1.65U PD=1.65U
* device instance $22 r0 *1 8.4,2 NMOS_VTG
M$22 1 4 9 9 NMOS_VTG L=0.05U W=0.25U AS=0.14375P AD=0.14375P PS=1.65U PD=1.65U
.ENDS DFF_V2_PN_COLUMN_NMOS_REVERSED_P1p8
