* cell DFF_V2_PN_COLUMN_GATE_SORTED_NMOS_REVERSED_P2p1
* pin Q
* pin CLK
* pin D
* pin VDD
* pin VSS
.SUBCKT DFF_V2_PN_COLUMN_GATE_SORTED_NMOS_REVERSED_P2p1 1 6 10 12 13
* net 1 Q
* net 6 CLK
* net 10 D
* net 12 VDD
* net 13 VSS
* device instance $1 r0 *1 22.2,7 PMOS_VTG
M$1 1 5 12 12 PMOS_VTG L=0.05U W=0.5U AS=0.2875P AD=0.2875P PS=2.15U PD=2.15U
* device instance $2 r0 *1 18,7 PMOS_VTG
M$2 3 8 12 12 PMOS_VTG L=0.05U W=0.5U AS=0.2875P AD=0.2875P PS=2.15U PD=2.15U
* device instance $3 r0 *1 15.9,7 PMOS_VTG
M$3 8 11 12 12 PMOS_VTG L=0.05U W=0.5U AS=0.2875P AD=0.2875P PS=2.15U PD=2.15U
* device instance $4 r0 *1 13.8,7 PMOS_VTG
M$4 9 1 12 12 PMOS_VTG L=0.05U W=0.5U AS=0.2875P AD=0.2875P PS=2.15U PD=2.15U
* device instance $5 r0 *1 20.1,7 PMOS_VTG
M$5 2 8 12 12 PMOS_VTG L=0.05U W=0.5U AS=0.2875P AD=0.2875P PS=2.15U PD=2.15U
* device instance $6 r0 *1 1.2,7 PMOS_VTG
M$6 7 6 12 12 PMOS_VTG L=0.05U W=0.5U AS=0.2875P AD=0.2875P PS=2.15U PD=2.15U
* device instance $7 r0 *1 3.3,7 PMOS_VTG
M$7 11 6 4 12 PMOS_VTG L=0.05U W=0.5U AS=0.2875P AD=0.2875P PS=2.15U PD=2.15U
* device instance $8 r0 *1 5.4,7 PMOS_VTG
M$8 5 6 9 12 PMOS_VTG L=0.05U W=0.5U AS=0.2875P AD=0.2875P PS=2.15U PD=2.15U
* device instance $9 r0 *1 7.5,7 PMOS_VTG
M$9 11 7 3 12 PMOS_VTG L=0.05U W=0.5U AS=0.2875P AD=0.2875P PS=2.15U PD=2.15U
* device instance $10 r0 *1 9.6,7 PMOS_VTG
M$10 5 7 2 12 PMOS_VTG L=0.05U W=0.5U AS=0.2875P AD=0.2875P PS=2.15U PD=2.15U
* device instance $11 r0 *1 11.7,7 PMOS_VTG
M$11 4 10 12 12 PMOS_VTG L=0.05U W=0.5U AS=0.2875P AD=0.2875P PS=2.15U PD=2.15U
* device instance $12 r0 *1 22.2,2 NMOS_VTG
M$12 7 6 13 13 NMOS_VTG L=0.05U W=0.25U AS=0.14375P AD=0.14375P PS=1.65U
+ PD=1.65U
* device instance $13 r0 *1 18,2 NMOS_VTG
M$13 2 6 5 13 NMOS_VTG L=0.05U W=0.25U AS=0.14375P AD=0.14375P PS=1.65U PD=1.65U
* device instance $14 r0 *1 15.9,2 NMOS_VTG
M$14 4 7 11 13 NMOS_VTG L=0.05U W=0.25U AS=0.14375P AD=0.14375P PS=1.65U
+ PD=1.65U
* device instance $15 r0 *1 20.1,2 NMOS_VTG
M$15 3 6 11 13 NMOS_VTG L=0.05U W=0.25U AS=0.14375P AD=0.14375P PS=1.65U
+ PD=1.65U
* device instance $16 r0 *1 13.8,2 NMOS_VTG
M$16 9 7 5 13 NMOS_VTG L=0.05U W=0.25U AS=0.14375P AD=0.14375P PS=1.65U PD=1.65U
* device instance $17 r0 *1 1.2,2 NMOS_VTG
M$17 1 5 13 13 NMOS_VTG L=0.05U W=0.25U AS=0.14375P AD=0.14375P PS=1.65U
+ PD=1.65U
* device instance $18 r0 *1 3.3,2 NMOS_VTG
M$18 2 8 13 13 NMOS_VTG L=0.05U W=0.25U AS=0.14375P AD=0.14375P PS=1.65U
+ PD=1.65U
* device instance $19 r0 *1 5.4,2 NMOS_VTG
M$19 3 8 13 13 NMOS_VTG L=0.05U W=0.25U AS=0.14375P AD=0.14375P PS=1.65U
+ PD=1.65U
* device instance $20 r0 *1 7.5,2 NMOS_VTG
M$20 8 11 13 13 NMOS_VTG L=0.05U W=0.25U AS=0.14375P AD=0.14375P PS=1.65U
+ PD=1.65U
* device instance $21 r0 *1 9.6,2 NMOS_VTG
M$21 9 1 13 13 NMOS_VTG L=0.05U W=0.25U AS=0.14375P AD=0.14375P PS=1.65U
+ PD=1.65U
* device instance $22 r0 *1 11.7,2 NMOS_VTG
M$22 4 10 13 13 NMOS_VTG L=0.05U W=0.25U AS=0.14375P AD=0.14375P PS=1.65U
+ PD=1.65U
.ENDS DFF_V2_PN_COLUMN_GATE_SORTED_NMOS_REVERSED_P2p1
