* cell DFF_V2_PN_COLUMN_GATE_SORTED_P2p4
* pin CLK
* pin D
* pin Q
* pin VDD
* pin VSS
.SUBCKT DFF_V2_PN_COLUMN_GATE_SORTED_P2p4 7 8 9 12 13
* net 7 CLK
* net 8 D
* net 9 Q
* net 12 VDD
* net 13 VSS
* device instance $1 r0 *1 25.2,7 PMOS_VTG
M$1 9 4 12 12 PMOS_VTG L=0.05U W=0.5U AS=0.2875P AD=0.2875P PS=2.15U PD=2.15U
* device instance $2 r0 *1 20.4,7 PMOS_VTG
M$2 3 6 12 12 PMOS_VTG L=0.05U W=0.5U AS=0.2875P AD=0.2875P PS=2.15U PD=2.15U
* device instance $3 r0 *1 22.8,7 PMOS_VTG
M$3 5 6 12 12 PMOS_VTG L=0.05U W=0.5U AS=0.2875P AD=0.2875P PS=2.15U PD=2.15U
* device instance $4 r0 *1 18,7 PMOS_VTG
M$4 6 2 12 12 PMOS_VTG L=0.05U W=0.5U AS=0.2875P AD=0.2875P PS=2.15U PD=2.15U
* device instance $5 r0 *1 1.2,7 PMOS_VTG
M$5 1 7 12 12 PMOS_VTG L=0.05U W=0.5U AS=0.2875P AD=0.2875P PS=2.15U PD=2.15U
* device instance $6 r0 *1 8.4,7 PMOS_VTG
M$6 2 1 3 12 PMOS_VTG L=0.05U W=0.5U AS=0.2875P AD=0.2875P PS=2.15U PD=2.15U
* device instance $7 r0 *1 3.6,7 PMOS_VTG
M$7 2 7 10 12 PMOS_VTG L=0.05U W=0.5U AS=0.2875P AD=0.2875P PS=2.15U PD=2.15U
* device instance $8 r0 *1 6,7 PMOS_VTG
M$8 4 7 11 12 PMOS_VTG L=0.05U W=0.5U AS=0.2875P AD=0.2875P PS=2.15U PD=2.15U
* device instance $9 r0 *1 13.2,7 PMOS_VTG
M$9 10 8 12 12 PMOS_VTG L=0.05U W=0.5U AS=0.2875P AD=0.2875P PS=2.15U PD=2.15U
* device instance $10 r0 *1 10.8,7 PMOS_VTG
M$10 4 1 5 12 PMOS_VTG L=0.05U W=0.5U AS=0.2875P AD=0.2875P PS=2.15U PD=2.15U
* device instance $11 r0 *1 15.6,7 PMOS_VTG
M$11 11 9 12 12 PMOS_VTG L=0.05U W=0.5U AS=0.2875P AD=0.2875P PS=2.15U PD=2.15U
* device instance $12 r0 *1 25.2,2 NMOS_VTG
M$12 9 4 13 13 NMOS_VTG L=0.05U W=0.25U AS=0.14375P AD=0.14375P PS=1.65U
+ PD=1.65U
* device instance $13 r0 *1 22.8,2 NMOS_VTG
M$13 5 6 13 13 NMOS_VTG L=0.05U W=0.25U AS=0.14375P AD=0.14375P PS=1.65U
+ PD=1.65U
* device instance $14 r0 *1 18,2 NMOS_VTG
M$14 6 2 13 13 NMOS_VTG L=0.05U W=0.25U AS=0.14375P AD=0.14375P PS=1.65U
+ PD=1.65U
* device instance $15 r0 *1 15.6,2 NMOS_VTG
M$15 11 9 13 13 NMOS_VTG L=0.05U W=0.25U AS=0.14375P AD=0.14375P PS=1.65U
+ PD=1.65U
* device instance $16 r0 *1 1.2,2 NMOS_VTG
M$16 1 7 13 13 NMOS_VTG L=0.05U W=0.25U AS=0.14375P AD=0.14375P PS=1.65U
+ PD=1.65U
* device instance $17 r0 *1 3.6,2 NMOS_VTG
M$17 3 7 2 13 NMOS_VTG L=0.05U W=0.25U AS=0.14375P AD=0.14375P PS=1.65U PD=1.65U
* device instance $18 r0 *1 6,2 NMOS_VTG
M$18 5 7 4 13 NMOS_VTG L=0.05U W=0.25U AS=0.14375P AD=0.14375P PS=1.65U PD=1.65U
* device instance $19 r0 *1 8.4,2 NMOS_VTG
M$19 10 1 2 13 NMOS_VTG L=0.05U W=0.25U AS=0.14375P AD=0.14375P PS=1.65U
+ PD=1.65U
* device instance $20 r0 *1 20.4,2 NMOS_VTG
M$20 3 6 13 13 NMOS_VTG L=0.05U W=0.25U AS=0.14375P AD=0.14375P PS=1.65U
+ PD=1.65U
* device instance $21 r0 *1 13.2,2 NMOS_VTG
M$21 10 8 13 13 NMOS_VTG L=0.05U W=0.25U AS=0.14375P AD=0.14375P PS=1.65U
+ PD=1.65U
* device instance $22 r0 *1 10.8,2 NMOS_VTG
M$22 11 1 4 13 NMOS_VTG L=0.05U W=0.25U AS=0.14375P AD=0.14375P PS=1.65U
+ PD=1.65U
.ENDS DFF_V2_PN_COLUMN_GATE_SORTED_P2p4
