* cell DFF_V2_PN_COLUMN_SOURCE_ORDER_P1p8
* pin Q
* pin D
* pin CLK
* pin VDD
* pin VSS
.SUBCKT DFF_V2_PN_COLUMN_SOURCE_ORDER_P1p8 5 7 10 11 12
* net 5 Q
* net 7 D
* net 10 CLK
* net 11 VDD
* net 12 VSS
* device instance $1 r0 *1 19.2,7 PMOS_VTG
M$1 9 10 6 11 PMOS_VTG L=0.05U W=0.5U AS=0.2875P AD=0.2875P PS=2.15U PD=2.15U
* device instance $2 r0 *1 17.4,7 PMOS_VTG
M$2 9 10 4 11 PMOS_VTG L=0.05U W=0.5U AS=0.2875P AD=0.2875P PS=2.15U PD=2.15U
* device instance $3 r0 *1 15.6,7 PMOS_VTG
M$3 8 10 3 11 PMOS_VTG L=0.05U W=0.5U AS=0.2875P AD=0.2875P PS=2.15U PD=2.15U
* device instance $4 r0 *1 13.8,7 PMOS_VTG
M$4 8 10 1 11 PMOS_VTG L=0.05U W=0.5U AS=0.2875P AD=0.2875P PS=2.15U PD=2.15U
* device instance $5 r0 *1 12,7 PMOS_VTG
M$5 6 5 11 11 PMOS_VTG L=0.05U W=0.5U AS=0.2875P AD=0.2875P PS=2.15U PD=2.15U
* device instance $6 r0 *1 1.2,7 PMOS_VTG
M$6 10 10 11 11 PMOS_VTG L=0.05U W=0.5U AS=0.2875P AD=0.2875P PS=2.15U PD=2.15U
* device instance $7 r0 *1 10.2,7 PMOS_VTG
M$7 5 9 11 11 PMOS_VTG L=0.05U W=0.5U AS=0.2875P AD=0.2875P PS=2.15U PD=2.15U
* device instance $8 r0 *1 3,7 PMOS_VTG
M$8 1 7 11 11 PMOS_VTG L=0.05U W=0.5U AS=0.2875P AD=0.2875P PS=2.15U PD=2.15U
* device instance $9 r0 *1 4.8,7 PMOS_VTG
M$9 2 8 11 11 PMOS_VTG L=0.05U W=0.5U AS=0.2875P AD=0.2875P PS=2.15U PD=2.15U
* device instance $10 r0 *1 6.6,7 PMOS_VTG
M$10 3 2 11 11 PMOS_VTG L=0.05U W=0.5U AS=0.2875P AD=0.2875P PS=2.15U PD=2.15U
* device instance $11 r0 *1 8.4,7 PMOS_VTG
M$11 4 2 11 11 PMOS_VTG L=0.05U W=0.5U AS=0.2875P AD=0.2875P PS=2.15U PD=2.15U
* device instance $12 r0 *1 19.2,2 NMOS_VTG
M$12 6 10 9 12 NMOS_VTG L=0.05U W=0.25U AS=0.14375P AD=0.14375P PS=1.65U
+ PD=1.65U
* device instance $13 r0 *1 15.6,2 NMOS_VTG
M$13 3 10 8 12 NMOS_VTG L=0.05U W=0.25U AS=0.14375P AD=0.14375P PS=1.65U
+ PD=1.65U
* device instance $14 r0 *1 13.8,2 NMOS_VTG
M$14 1 10 8 12 NMOS_VTG L=0.05U W=0.25U AS=0.14375P AD=0.14375P PS=1.65U
+ PD=1.65U
* device instance $15 r0 *1 12,2 NMOS_VTG
M$15 6 5 12 12 NMOS_VTG L=0.05U W=0.25U AS=0.14375P AD=0.14375P PS=1.65U
+ PD=1.65U
* device instance $16 r0 *1 1.2,2 NMOS_VTG
M$16 10 10 12 12 NMOS_VTG L=0.05U W=0.25U AS=0.14375P AD=0.14375P PS=1.65U
+ PD=1.65U
* device instance $17 r0 *1 17.4,2 NMOS_VTG
M$17 4 10 9 12 NMOS_VTG L=0.05U W=0.25U AS=0.14375P AD=0.14375P PS=1.65U
+ PD=1.65U
* device instance $18 r0 *1 6.6,2 NMOS_VTG
M$18 3 2 12 12 NMOS_VTG L=0.05U W=0.25U AS=0.14375P AD=0.14375P PS=1.65U
+ PD=1.65U
* device instance $19 r0 *1 3,2 NMOS_VTG
M$19 1 7 12 12 NMOS_VTG L=0.05U W=0.25U AS=0.14375P AD=0.14375P PS=1.65U
+ PD=1.65U
* device instance $20 r0 *1 10.2,2 NMOS_VTG
M$20 5 9 12 12 NMOS_VTG L=0.05U W=0.25U AS=0.14375P AD=0.14375P PS=1.65U
+ PD=1.65U
* device instance $21 r0 *1 4.8,2 NMOS_VTG
M$21 2 8 12 12 NMOS_VTG L=0.05U W=0.25U AS=0.14375P AD=0.14375P PS=1.65U
+ PD=1.65U
* device instance $22 r0 *1 8.4,2 NMOS_VTG
M$22 4 2 12 12 NMOS_VTG L=0.05U W=0.25U AS=0.14375P AD=0.14375P PS=1.65U
+ PD=1.65U
.ENDS DFF_V2_PN_COLUMN_SOURCE_ORDER_P1p8
