.include "/tmp/qujh_delay_chain_scratch/storage_relief_20260725/worktrees/project_mainline_inventory_20260726/outputs/PROJECT_openyield_dff_routing_aware_feol_beol_co_optimization/VERIFY/dff_openyield_original.sp"
.subckt BROKEN_CLK_D_SHORT_COLUMN_FIXTURE VDD VSS D Q CLK
Xdut VDD VSS D Q CLK dff_openyield_original
.ends BROKEN_CLK_D_SHORT_COLUMN_FIXTURE
.end
