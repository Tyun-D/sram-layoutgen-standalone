* cell BROKEN_CLK_D_SHORT_COLUMN_FIXTURE
* pin Q
* pin CLK,D,VDD,VSS
.SUBCKT BROKEN_CLK_D_SHORT_COLUMN_FIXTURE 2 3
* net 2 Q
* net 3 CLK,D,VDD,VSS
* device instance $1 r0 *1 19.2,7 PMOS_VTG
M$1 2 3 3 3 PMOS_VTG L=0.05U W=0.5U AS=0.2875P AD=0.2875P PS=2.15U PD=2.15U
* device instance $2 r0 *1 17.4,7 PMOS_VTG
M$2 3 1 3 3 PMOS_VTG L=0.05U W=1U AS=0.575P AD=0.575P PS=4.3U PD=4.3U
* device instance $4 r0 *1 13.8,7 PMOS_VTG
M$4 1 3 3 3 PMOS_VTG L=0.05U W=0.5U AS=0.2875P AD=0.2875P PS=2.15U PD=2.15U
* device instance $5 r0 *1 12,7 PMOS_VTG
M$5 3 2 3 3 PMOS_VTG L=0.05U W=0.5U AS=0.2875P AD=0.2875P PS=2.15U PD=2.15U
* device instance $6 r0 *1 1.2,7 PMOS_VTG
M$6 3 3 3 3 PMOS_VTG L=0.05U W=3U AS=1.725P AD=1.725P PS=12.9U PD=12.9U
* device instance $12 r0 *1 19.2,2 NMOS_VTG
M$12 2 3 3 3 NMOS_VTG L=0.05U W=0.25U AS=0.14375P AD=0.14375P PS=1.65U PD=1.65U
* device instance $13 r0 *1 15.6,2 NMOS_VTG
M$13 3 1 3 3 NMOS_VTG L=0.05U W=0.5U AS=0.2875P AD=0.2875P PS=3.3U PD=3.3U
* device instance $14 r0 *1 13.8,2 NMOS_VTG
M$14 1 3 3 3 NMOS_VTG L=0.05U W=0.25U AS=0.14375P AD=0.14375P PS=1.65U PD=1.65U
* device instance $15 r0 *1 12,2 NMOS_VTG
M$15 3 2 3 3 NMOS_VTG L=0.05U W=0.25U AS=0.14375P AD=0.14375P PS=1.65U PD=1.65U
* device instance $16 r0 *1 1.2,2 NMOS_VTG
M$16 3 3 3 3 NMOS_VTG L=0.05U W=1.5U AS=0.8625P AD=0.8625P PS=9.9U PD=9.9U
.ENDS BROKEN_CLK_D_SHORT_COLUMN_FIXTURE
